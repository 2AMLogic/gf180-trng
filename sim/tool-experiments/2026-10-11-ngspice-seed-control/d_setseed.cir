seed probe D: .option seed=11, control setseed 12
.param pm = agauss(0, 1, 1)
vn n1 0 dc 0 trnoise(1 1n 0 0)
rn n1 0 1k
bp n2 0 v = pm
rp n2 0 1k
.option seed=11
.control
setseed 12
set numdgt=8
tran 1n 6n
print v(n1)
let p = v(n2)
print p[0]
let g = sgauss(vector(3))
print g
.endc
.end
