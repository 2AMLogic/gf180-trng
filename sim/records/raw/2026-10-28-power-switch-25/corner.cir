* klt sim -- generated corner deck, do not edit
.lib /opt/pdk/gf180mcuD/libs.tech/ngspice/sm141064.ngspice ss
.lib /opt/pdk/gf180mcuD/libs.tech/ngspice/sm141064.ngspice bjt_ss
.lib /opt/pdk/gf180mcuD/libs.tech/ngspice/sm141064.ngspice diode_ss
.lib /opt/pdk/gf180mcuD/libs.tech/ngspice/sm141064.ngspice res_ss
.lib /opt/pdk/gf180mcuD/libs.tech/ngspice/sm141064.ngspice moscap_ss
.lib /opt/pdk/gf180mcuD/libs.tech/ngspice/sm141064.ngspice mimcap_ss
.include /var/tmp/eda-job-klt-sim-1d495bf31dde/inputs/netlist.cir
.temp -40
.meas tran droop_1a find par('v(vdd)-v(vr1a)') at=2.9u
.meas tran droop_1b find par('v(vdd)-v(vr1b)') at=2.9u
.meas tran ileak_1 find i(vl1) at=2.9u
.meas tran droop_2a find par('v(vdd)-v(vr2a)') at=2.9u
.meas tran droop_2b find par('v(vdd)-v(vr2b)') at=2.9u
.meas tran ileak_2 find i(vl2) at=2.9u
.meas tran droop_4a find par('v(vdd)-v(vr4a)') at=2.9u
.meas tran droop_4b find par('v(vdd)-v(vr4b)') at=2.9u
.meas tran ileak_4 find i(vl4) at=2.9u
.meas tran droop_8a find par('v(vdd)-v(vr8a)') at=2.9u
.meas tran droop_8b find par('v(vdd)-v(vr8b)') at=2.9u
.meas tran ileak_8 find i(vl8) at=2.9u
.meas tran i_stack find i(vwst) at=2.9u
.meas tran v_stack find v(vst) at=2.9u
.meas tran i_ungated find i(vwun) at=2.9u
.meas tran ipk_w1 max i(vww1) from=90n to=3.5u
.meas tran t95_w1 when v(c1)=0 rise=1
.meas tran vfin_w1 find v(vw1) at=3.4u
.meas tran ipk_w2 max i(vww2) from=90n to=3.5u
.meas tran t95_w2 when v(c2)=0 rise=1
.meas tran vfin_w2 find v(vw2) at=3.4u
.meas tran ipk_w3 max i(vww3) from=90n to=3.5u
.meas tran t95_w3 when v(c3)=0 rise=1
.meas tran vfin_w3 find v(vw3) at=3.4u
.meas tran ipk_w4 max i(vww4) from=90n to=3.5u
.meas tran t95_w4 when v(c4)=0 rise=1
.meas tran vfin_w4 find v(vw4) at=3.4u
.control
save all
alter vsup=3.63
tran 100p 3.5u
quit
.endc
.end
