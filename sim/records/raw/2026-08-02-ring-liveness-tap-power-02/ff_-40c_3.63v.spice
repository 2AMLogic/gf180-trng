* ring-liveness-tap-power @ ff_-40c_3.63v -- GENERATED by sim/harness, do not edit
* corner=ff (all device families fast)
* temp=-40.0 C  vdd=3.63 V  pdk=gf180mcuD@c6d73a35f524070e85faff4a6a9eef49553ebc2b

* ---- PVT parameters -------------------------------------------------
.param vdd_nom=3.3
.param vdd_val=3.63
.param temp_c=-40.0

* ---- gf180mcu models ------------------------------------------------
.include "/Users/rwalters/.volare/gf180mcuD/libs.tech/ngspice/design.ngspice"
.lib "/Users/rwalters/.volare/gf180mcuD/libs.tech/ngspice/sm141064.ngspice" ff
.lib "/Users/rwalters/.volare/gf180mcuD/libs.tech/ngspice/sm141064.ngspice" bjt_ff
.lib "/Users/rwalters/.volare/gf180mcuD/libs.tech/ngspice/sm141064.ngspice" diode_ff
.lib "/Users/rwalters/.volare/gf180mcuD/libs.tech/ngspice/sm141064.ngspice" res_ff
.lib "/Users/rwalters/.volare/gf180mcuD/libs.tech/ngspice/sm141064.ngspice" moscap_ff
.lib "/Users/rwalters/.volare/gf180mcuD/libs.tech/ngspice/sm141064.ngspice" mimcap_ff

.temp -40.0

* ---- device under test (schematic-derived, design/netlist.py) -------
.include "/Users/rwalters/GitHub/gf180-trng/.loom/worktrees/issue-44/design/sampler_core.spice"

* ---- testbench ------------------------------------------------------
.include "/Users/rwalters/GitHub/gf180-trng/.loom/worktrees/issue-44/sim/tb/ring-liveness-tap-power/tb_ring_liveness_tap_power.sp"

* ---- measurement ----------------------------------------------------
.control
set numdgt=10
set noaskquit
  tran 1p 50n
  meas tran t1a when v(xdut.ro1)=v(vth) rise=2
  meas tran t1b when v(xdut.ro1)=v(vth) rise=6
  meas tran t2a when v(xdut.ro2)=v(vth) rise=2
  meas tran t2b when v(xdut.ro2)=v(vth) rise=6
  meas tran c1a find v(q1) when v(xdut.ro1)=v(vth) rise=2
  meas tran c1b find v(q1) when v(xdut.ro1)=v(vth) rise=6
  meas tran c2a find v(q2) when v(xdut.ro2)=v(vth) rise=2
  meas tran c2b find v(q2) when v(xdut.ro2)=v(vth) rise=6
  meas tran cta find v(qt) when v(xdut.ro1)=v(vth) rise=2
  meas tran ctb find v(qt) when v(xdut.ro1)=v(vth) rise=6
  meas tran vhi max v(xdut.ro1) from=25n to=48n
  meas tran vlo min v(xdut.ro1) from=25n to=48n
  meas tran vxhi max v(xo) from=25n to=48n
  meas tran vxlo min v(xo) from=25n to=48n
  meas tran qtap_end find v(qtap) at=48n
  meas tran ro1b_end find v(ro1_bit) at=48n
  meas tran ro2b_end find v(ro2_bit) at=48n
  let cq = 1e-9
  let nper = 4
  let nstg = 11
  let m_period_r1 = (t1b-t1a)/nper
  let m_period_r2 = (t2b-t2a)/nper
  let m_f_r1 = nper/(t1b-t1a)
  let m_f_r2 = nper/(t2b-t2a)
  let m_i_r1_a = cq*(c1b-c1a)/(t1b-t1a)
  let m_i_r2_a = cq*(c2b-c2a)/(t2b-t2a)
  let m_i_tree_a = cq*(ctb-cta)/(t1b-t1a)
  let m_ring_swing_v = vhi-vlo
  let m_xo_swing_v = vxhi-vxlo
  let m_p_rings_w = cq*((c1b-c1a)/(t1b-t1a)+(c2b-c2a)/(t2b-t2a))*mean(v(vsup))
  let m_p_total_w = cq*((c1b-c1a)/(t1b-t1a)+(c2b-c2a)/(t2b-t2a)+(ctb-cta)/(t1b-t1a))*mean(v(vsup))
  let m_i_tap_avg_a = cq*qtap_end/48n
  let m_p_tap_avg_w = cq*qtap_end/48n*mean(v(vsup))
  let m_ro1_bit_end_v = ro1b_end
  let m_ro2_bit_end_v = ro2b_end
  let m_ro1_bit_rail_dev_v = min(ro1b_end, mean(v(vsup))-ro1b_end)
  let m_ro2_bit_rail_dev_v = min(ro2b_end, mean(v(vsup))-ro2b_end)
  print m_period_r1
  print m_period_r2
  print m_f_r1
  print m_f_r2
  print m_i_r1_a
  print m_i_r2_a
  print m_i_tree_a
  print m_ring_swing_v
  print m_xo_swing_v
  print m_p_rings_w
  print m_p_total_w
  print m_i_tap_avg_a
  print m_p_tap_avg_w
  print m_ro1_bit_end_v
  print m_ro2_bit_end_v
  print m_ro1_bit_rail_dev_v
  print m_ro2_bit_rail_dev_v
.endc
.end
