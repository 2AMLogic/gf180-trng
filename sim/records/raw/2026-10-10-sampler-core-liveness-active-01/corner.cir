* klt sim -- generated corner deck, do not edit
.lib ~/.volare/gf180mcuD/libs.tech/ngspice/sm141064.ngspice typical
.lib ~/.volare/gf180mcuD/libs.tech/ngspice/sm141064.ngspice bjt_typical
.lib ~/.volare/gf180mcuD/libs.tech/ngspice/sm141064.ngspice diode_typical
.lib ~/.volare/gf180mcuD/libs.tech/ngspice/sm141064.ngspice res_typical
.lib ~/.volare/gf180mcuD/libs.tech/ngspice/sm141064.ngspice moscap_typical
.lib ~/.volare/gf180mcuD/libs.tech/ngspice/sm141064.ngspice mimcap_typical
.include <repo>/sim/tb/sampler-core-liveness-active/tb_sampler_core_liveness_active.sp
.temp 27
.meas tran t1a when v(ro1)=v(vth) rise=2
.meas tran t1b when v(ro1)=v(vth) rise=6
.meas tran t2a when v(ro2)=v(vth) rise=2
.meas tran t2b when v(ro2)=v(vth) rise=6
.meas tran tc1a when v(cro1)=v(vth) rise=2
.meas tran tc1b when v(cro1)=v(vth) rise=6
.meas tran tc2a when v(cro2)=v(vth) rise=2
.meas tran tc2b when v(cro2)=v(vth) rise=6
.meas tran q1_1a find v(q1) when v(ro1)=v(vth) rise=2
.meas tran q1_1b find v(q1) when v(ro1)=v(vth) rise=6
.meas tran qt_1a find v(qt) when v(ro1)=v(vth) rise=2
.meas tran qt_1b find v(qt) when v(ro1)=v(vth) rise=6
.meas tran qsb_1a find v(qsb) when v(ro1)=v(vth) rise=2
.meas tran qsb_1b find v(qsb) when v(ro1)=v(vth) rise=6
.meas tran qsv_1a find v(qsv) when v(ro1)=v(vth) rise=2
.meas tran qsv_1b find v(qsv) when v(ro1)=v(vth) rise=6
.meas tran qs1_1a find v(qs1) when v(ro1)=v(vth) rise=2
.meas tran qs1_1b find v(qs1) when v(ro1)=v(vth) rise=6
.meas tran q2_2a find v(q2) when v(ro2)=v(vth) rise=2
.meas tran q2_2b find v(q2) when v(ro2)=v(vth) rise=6
.meas tran qsv_2a find v(qsv) when v(ro2)=v(vth) rise=2
.meas tran qsv_2b find v(qsv) when v(ro2)=v(vth) rise=6
.meas tran qs2_2a find v(qs2) when v(ro2)=v(vth) rise=2
.meas tran qs2_2b find v(qs2) when v(ro2)=v(vth) rise=6
.meas tran cq1i_c1a find v(cq1i) when v(cro1)=v(vth) rise=2
.meas tran cq1i_c1b find v(cq1i) when v(cro1)=v(vth) rise=6
.meas tran cqt_c1a find v(cqt) when v(cro1)=v(vth) rise=2
.meas tran cqt_c1b find v(cqt) when v(cro1)=v(vth) rise=6
.meas tran cqsb_c1a find v(cqsb) when v(cro1)=v(vth) rise=2
.meas tran cqsb_c1b find v(cqsb) when v(cro1)=v(vth) rise=6
.meas tran cqsv_c1a find v(cqsv) when v(cro1)=v(vth) rise=2
.meas tran cqsv_c1b find v(cqsv) when v(cro1)=v(vth) rise=6
.meas tran cq2i_c2a find v(cq2i) when v(cro2)=v(vth) rise=2
.meas tran cq2i_c2b find v(cq2i) when v(cro2)=v(vth) rise=6
.meas tran ring1_max max v(ro1) from=60n to=118n
.meas tran ring1_min min v(ro1) from=60n to=118n
.meas tran ring2_max max v(ro2) from=60n to=118n
.meas tran ring2_min min v(ro2) from=60n to=118n
.control
save all
alter vsupply=3.3
tran 5p 120n
quit
.endc
.end
