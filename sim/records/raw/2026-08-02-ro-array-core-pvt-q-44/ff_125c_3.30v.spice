* ro-array-core-pvt-q @ ff_125c_3.30v -- GENERATED by sim/harness, do not edit
* corner=ff (all device families fast)
* temp=125.0 C  vdd=3.3 V  pdk=gf180mcuD@c6d73a35f524070e85faff4a6a9eef49553ebc2b

* ---- PVT parameters -------------------------------------------------
.param vdd_nom=3.3
.param vdd_val=3.3
.param temp_c=125.0

* ---- gf180mcu models ------------------------------------------------
.include "/Users/rwalters/.volare/gf180mcuD/libs.tech/ngspice/design.ngspice"
.lib "/Users/rwalters/.volare/gf180mcuD/libs.tech/ngspice/sm141064.ngspice" ff
.lib "/Users/rwalters/.volare/gf180mcuD/libs.tech/ngspice/sm141064.ngspice" bjt_ff
.lib "/Users/rwalters/.volare/gf180mcuD/libs.tech/ngspice/sm141064.ngspice" diode_ff
.lib "/Users/rwalters/.volare/gf180mcuD/libs.tech/ngspice/sm141064.ngspice" res_ff
.lib "/Users/rwalters/.volare/gf180mcuD/libs.tech/ngspice/sm141064.ngspice" moscap_ff
.lib "/Users/rwalters/.volare/gf180mcuD/libs.tech/ngspice/sm141064.ngspice" mimcap_ff

.temp 125.0

* ---- device under test (schematic-derived, design/netlist.py) -------
.include "/Users/rwalters/GitHub/gf180-trng/.loom/worktrees/issue-78/design/ro_array_core.spice"

* ---- testbench ------------------------------------------------------
.include "/Users/rwalters/GitHub/gf180-trng/.loom/worktrees/issue-78/sim/tb/ro-array-core-pvt-q/tb_ro_array_core_pvt_q.sp"

* ---- measurement ----------------------------------------------------
.control
set numdgt=10
set noaskquit
  tran 5p 300n
  meas tran t1a when v(ro1)=v(vth) rise=2
  meas tran t1b when v(ro1)=v(vth) rise=6
  meas tran t2a when v(ro2)=v(vth) rise=2
  meas tran t2b when v(ro2)=v(vth) rise=6
  meas tran c1a find v(q1) when v(ro1)=v(vth) rise=2
  meas tran c1b find v(q1) when v(ro1)=v(vth) rise=6
  meas tran c2a find v(q2) when v(ro2)=v(vth) rise=2
  meas tran c2b find v(q2) when v(ro2)=v(vth) rise=6
  meas tran cta find v(qt) when v(ro1)=v(vth) rise=2
  meas tran ctb find v(qt) when v(ro1)=v(vth) rise=6
  meas tran vhi max v(ro1) from=200n to=295n
  meas tran vlo min v(ro1) from=200n to=295n
  meas tran vxhi max v(xo) from=200n to=295n
  meas tran vxlo min v(xo) from=200n to=295n
  let cq = 1e-9
  let nper = 4
  let nstg = 11
  let m_period_r1 = (t1b-t1a)/nper
  let m_period_r2 = (t2b-t2a)/nper
  let m_f_r1 = nper/(t1b-t1a)
  let m_f_r2 = nper/(t2b-t2a)
  let m_i_r1_a = cq*(c1b-c1a)/(t1b-t1a)
  let m_i_r2_a = cq*(c2b-c2a)/(t2b-t2a)
  let m_i_tree_a = cq*(ctb-cta)/(t1b-t1a)
  let m_e_cycle_r1_j = cq*(c1b-c1a)/nper*mean(v(vsup))
  let m_c_eff_node_r1_f = cq*(c1b-c1a)/(nper*nstg*mean(v(vsup)))
  let m_ring_swing_v = vhi-vlo
  let m_xo_swing_v = vxhi-vxlo
  let m_i_total_a = cq*((c1b-c1a)/(t1b-t1a)+(c2b-c2a)/(t2b-t2a)+(ctb-cta)/(t1b-t1a))
  let m_p_rings_w = cq*((c1b-c1a)/(t1b-t1a)+(c2b-c2a)/(t2b-t2a))*mean(v(vsup))
  let m_p_total_w = cq*((c1b-c1a)/(t1b-t1a)+(c2b-c2a)/(t2b-t2a)+(ctb-cta)/(t1b-t1a))*mean(v(vsup))
  let m_xo_trans_per_s = 2*(nper/(t1b-t1a)+nper/(t2b-t2a))
  print m_period_r1
  print m_period_r2
  print m_f_r1
  print m_f_r2
  print m_i_r1_a
  print m_i_r2_a
  print m_i_tree_a
  print m_e_cycle_r1_j
  print m_c_eff_node_r1_f
  print m_ring_swing_v
  print m_xo_swing_v
  print m_i_total_a
  print m_p_rings_w
  print m_p_total_w
  print m_xo_trans_per_s
.endc
.end
