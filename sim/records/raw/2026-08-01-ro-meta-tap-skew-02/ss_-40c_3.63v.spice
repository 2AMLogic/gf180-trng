* ro-meta-tap-skew @ ss_-40c_3.63v -- GENERATED by sim/harness, do not edit
* corner=ss (all device families slow)
* temp=-40.0 C  vdd=3.63 V  pdk=gf180mcuD@c6d73a35f524070e85faff4a6a9eef49553ebc2b

* ---- PVT parameters -------------------------------------------------
.param vdd_nom=3.3
.param vdd_val=3.63
.param temp_c=-40.0

* ---- gf180mcu models ------------------------------------------------
.include "/Users/rwalters/.volare/gf180mcuD/libs.tech/ngspice/design.ngspice"
.lib "/Users/rwalters/.volare/gf180mcuD/libs.tech/ngspice/sm141064.ngspice" ss
.lib "/Users/rwalters/.volare/gf180mcuD/libs.tech/ngspice/sm141064.ngspice" bjt_ss
.lib "/Users/rwalters/.volare/gf180mcuD/libs.tech/ngspice/sm141064.ngspice" diode_ss
.lib "/Users/rwalters/.volare/gf180mcuD/libs.tech/ngspice/sm141064.ngspice" res_ss
.lib "/Users/rwalters/.volare/gf180mcuD/libs.tech/ngspice/sm141064.ngspice" moscap_ss
.lib "/Users/rwalters/.volare/gf180mcuD/libs.tech/ngspice/sm141064.ngspice" mimcap_ss

.temp -40.0
.options reltol=1e-5

* ---- device under test (schematic-derived, design/netlist.py) -------
.include "/Users/rwalters/GitHub/gf180-trng/.loom/worktrees/issue-43/design/ro_meta_tap.spice"

* ---- testbench ------------------------------------------------------
.include "/Users/rwalters/GitHub/gf180-trng/.loom/worktrees/issue-43/sim/tb/ro-meta-tap-skew/tb_ro_meta_tap_skew.sp"

* ---- measurement ----------------------------------------------------
.control
set numdgt=10
set noaskquit
  tran 0.2p 12n
  meas tran txf when v(xin)=v(vth) fall=1
  meas tran ta1 when v(xt1.pa)=v(vth) rise=1
  meas tran tb1 when v(xt1.pb)=v(vth) rise=1
  meas tran ta2 when v(xt2.pa)=v(vth) rise=1
  meas tran tb2 when v(xt2.pb)=v(vth) rise=1
  meas tran ta3 when v(xt3.pa)=v(vth) rise=1
  meas tran tb3 when v(xt3.pb)=v(vth) rise=1
  meas tran ta4 when v(xt4.pa)=v(vth) rise=1
  meas tran tb4 when v(xt4.pb)=v(vth) rise=1
  meas tran tq2 when v(xt2.mq)=v(vth) fall=1
  meas tran tq4 when v(xt4.mq)=v(vth) fall=1
  meas tran vmo find v(mo4) at=9.5n
  meas tran tpa when v(xinp)=v(vth) rise=2
  meas tran tpb when v(xinp)=v(vth) rise=6
  meas tran cpa find v(qp) when v(xinp)=v(vth) rise=2
  meas tran cpb find v(qp) when v(xinp)=v(vth) rise=6
  let cq = 1e-9
  let nper = 4
  let m_dt_005ff_s = tb1-ta1
  let m_dt_05ff_s = tb2-ta2
  let m_dt_1ff_s = tb3-ta3
  let m_dt_2ff_s = tb4-ta4
  let m_dt_per_ff_s = (tb4-ta4)/2
  let m_lin_2ff_over_1ff = (tb4-ta4)/(tb3-ta3)
  let m_t_path_s = ta1-txf
  let m_t_res_05ff_s = tq2-ta2
  let m_t_res_2ff_s = tq4-ta4
  let m_mo_final_v = vmo
  let m_i_tap_a = cq*(cpb-cpa)/(tpb-tpa)
  let m_p_tap_w = cq*(cpb-cpa)/(tpb-tpa)*mean(v(vsup))
  let m_e_period_j = cq*(cpb-cpa)/nper*mean(v(vsup))
  let m_f_drive_hz = nper/(tpb-tpa)
  print m_dt_005ff_s
  print m_dt_05ff_s
  print m_dt_1ff_s
  print m_dt_2ff_s
  print m_dt_per_ff_s
  print m_lin_2ff_over_1ff
  print m_t_path_s
  print m_t_res_05ff_s
  print m_t_res_2ff_s
  print m_mo_final_v
  print m_i_tap_a
  print m_p_tap_w
  print m_e_period_j
  print m_f_drive_hz
.endc
.end
