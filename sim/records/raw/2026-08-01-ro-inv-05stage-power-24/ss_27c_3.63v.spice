* ro-inv-05stage-power @ ss_27c_3.63v -- GENERATED by sim/harness, do not edit
* corner=ss (all device families slow)
* temp=27.0 C  vdd=3.63 V  pdk=gf180mcuD@c6d73a35f524070e85faff4a6a9eef49553ebc2b

* ---- PVT parameters -------------------------------------------------
.param vdd_nom=3.3
.param vdd_val=3.63
.param temp_c=27.0

* ---- gf180mcu models ------------------------------------------------
.include "/Users/rwalters/.volare/gf180mcuD/libs.tech/ngspice/design.ngspice"
.lib "/Users/rwalters/.volare/gf180mcuD/libs.tech/ngspice/sm141064.ngspice" ss
.lib "/Users/rwalters/.volare/gf180mcuD/libs.tech/ngspice/sm141064.ngspice" bjt_ss
.lib "/Users/rwalters/.volare/gf180mcuD/libs.tech/ngspice/sm141064.ngspice" diode_ss
.lib "/Users/rwalters/.volare/gf180mcuD/libs.tech/ngspice/sm141064.ngspice" res_ss
.lib "/Users/rwalters/.volare/gf180mcuD/libs.tech/ngspice/sm141064.ngspice" moscap_ss
.lib "/Users/rwalters/.volare/gf180mcuD/libs.tech/ngspice/sm141064.ngspice" mimcap_ss

.temp 27.0

* ---- testbench ------------------------------------------------------
.include "/Users/rwalters/GitHub/gf180-trng/.loom/worktrees/issue-32/sim/tb/ro-inv-05stage-power/tb_ro_inv_05stage_power.sp"

* ---- measurement ----------------------------------------------------
.control
set numdgt=10
set noaskquit
  tran 1p 45n
  meas tran t1 when v(xing)=0 rise=3
  meas tran t2 when v(xing)=0 rise=19
  meas tran t3 when v(xing)=0 rise=35
  meas tran q1 find v(q) when v(xing)=0 rise=3
  meas tran q2 find v(q) when v(xing)=0 rise=19
  meas tran q3 find v(q) when v(xing)=0 rise=35
  let cq = 1e-9
  let nper = 32
  let m_period = (t3-t1)/nper
  let m_f_osc = nper/(t3-t1)
  let m_i_supply_a = cq*(q3-q1)/(t3-t1)
  let m_p_active_w = cq*(q3-q1)/(t3-t1)*mean(v(vdd))
  let m_e_per_cycle_j = cq*(q3-q1)/nper*mean(v(vdd))
  let m_c_eff_node_f = cq*(q3-q1)/(nper*5*mean(v(vdd)))
  let m_i_supply_first16_a = cq*(q2-q1)/(t2-t1)
  let m_i_supply_last16_a = cq*(q3-q2)/(t3-t2)
  print m_period
  print m_f_osc
  print m_i_supply_a
  print m_p_active_w
  print m_e_per_cycle_j
  print m_c_eff_node_f
  print m_i_supply_first16_a
  print m_i_supply_last16_a
.endc
.end
