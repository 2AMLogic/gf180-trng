* ro-array-core-mc-freq-extracted @ ss_125c_3.63v -- GENERATED by sim/harness, do not edit
* corner=ss (all device families slow)
* temp=125.0 C  vdd=3.63 V  pdk=gf180mcuD@f6eeac7dad085ffcc829ccfd721f7b4ce39edcf7

* ---- PVT parameters -------------------------------------------------
.param vdd_nom=3.3
.param vdd_val=3.63
.param temp_c=125.0

* ---- gf180mcu models ------------------------------------------------
.include "/home/ubuntu/.ciel/gf180mcuD/libs.tech/ngspice/design.ngspice"
.option seed=2
.param sw_stat_mismatch=1
.lib "/home/ubuntu/.ciel/gf180mcuD/libs.tech/ngspice/sm141064.ngspice" ss
.lib "/home/ubuntu/.ciel/gf180mcuD/libs.tech/ngspice/sm141064.ngspice" bjt_ss
.lib "/home/ubuntu/.ciel/gf180mcuD/libs.tech/ngspice/sm141064.ngspice" diode_ss
.lib "/home/ubuntu/.ciel/gf180mcuD/libs.tech/ngspice/sm141064.ngspice" res_ss
.lib "/home/ubuntu/.ciel/gf180mcuD/libs.tech/ngspice/sm141064.ngspice" moscap_ss
.lib "/home/ubuntu/.ciel/gf180mcuD/libs.tech/ngspice/sm141064.ngspice" mimcap_ss

.temp 125.0

* ---- device under test (schematic-derived, design/netlist.py) -------
.include "/home/ubuntu/GitHub/gf180-trng/.loom/worktrees/issue-17/layout/pex/ro_array_core.extracted.spice"

* ---- testbench ------------------------------------------------------
.include "/home/ubuntu/GitHub/gf180-trng/.loom/worktrees/issue-17/sim/tb/ro-array-core-mc-freq-extracted/tb_ro_array_core_mc_freq_extracted.sp"

* ---- measurement ----------------------------------------------------
.control
set numdgt=10
set noaskquit
  tran 1p 100n
  meas tran t1a when v(ro1)=v(vth) rise=2
  meas tran t1b when v(ro1)=v(vth) rise=6
  meas tran t2a when v(ro2)=v(vth) rise=2
  meas tran t2b when v(ro2)=v(vth) rise=6
  meas tran c1a find v(q1) when v(ro1)=v(vth) rise=2
  meas tran c1b find v(q1) when v(ro1)=v(vth) rise=6
  meas tran c2a find v(q2) when v(ro2)=v(vth) rise=2
  meas tran c2b find v(q2) when v(ro2)=v(vth) rise=6
  let cq = 1e-9
  let nper = 4
  let m_period_r1 = (t1b-t1a)/nper
  let m_period_r2 = (t2b-t2a)/nper
  let m_f_r1 = nper/(t1b-t1a)
  let m_f_r2 = nper/(t2b-t2a)
  let m_i_r1_a = cq*(c1b-c1a)/(t1b-t1a)
  let m_i_r2_a = cq*(c2b-c2a)/(t2b-t2a)
  print m_period_r1
  print m_period_r2
  print m_f_r1
  print m_f_r2
  print m_i_r1_a
  print m_i_r2_a
.endc
.end
