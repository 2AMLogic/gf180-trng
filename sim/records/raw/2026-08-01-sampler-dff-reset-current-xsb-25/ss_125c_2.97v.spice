* sampler-dff-reset-current-xsb @ ss_125c_2.97v -- GENERATED by sim/harness, do not edit
* corner=ss (all device families slow)
* temp=125.0 C  vdd=2.97 V  pdk=gf180mcuD@c6d73a35f524070e85faff4a6a9eef49553ebc2b

* ---- PVT parameters -------------------------------------------------
.param vdd_nom=3.3
.param vdd_val=2.97
.param temp_c=125.0

* ---- gf180mcu models ------------------------------------------------
.include "/Users/rwalters/.volare/gf180mcuD/libs.tech/ngspice/design.ngspice"
.lib "/Users/rwalters/.volare/gf180mcuD/libs.tech/ngspice/sm141064.ngspice" ss
.lib "/Users/rwalters/.volare/gf180mcuD/libs.tech/ngspice/sm141064.ngspice" bjt_ss
.lib "/Users/rwalters/.volare/gf180mcuD/libs.tech/ngspice/sm141064.ngspice" diode_ss
.lib "/Users/rwalters/.volare/gf180mcuD/libs.tech/ngspice/sm141064.ngspice" res_ss
.lib "/Users/rwalters/.volare/gf180mcuD/libs.tech/ngspice/sm141064.ngspice" moscap_ss
.lib "/Users/rwalters/.volare/gf180mcuD/libs.tech/ngspice/sm141064.ngspice" mimcap_ss

.temp 125.0

* ---- device under test (schematic-derived, design/netlist.py) -------
.include "/Users/rwalters/GitHub/gf180-trng/.loom/worktrees/issue-48/design/sampler_core.spice"

* ---- testbench ------------------------------------------------------
.include "/Users/rwalters/GitHub/gf180-trng/.loom/worktrees/issue-48/sim/tb/sampler-dff-reset-current-xsb/tb_sampler_dff_reset_current_xsb.sp"

* ---- measurement ----------------------------------------------------
.control
set numdgt=10
set noaskquit
  tran 1p 4.6n
  meas tran qint1 find v(qint) at=0.5n
  meas tran qint2 find v(qint) at=2.5n
  meas tran qint3 find v(qint) at=4.5n
  meas tran qout_rst find v(q) at=0.5n
  let cq = 1e-9
  let m_i_reset_xsb_a = cq*(qint3-qint1)/4e-9
  let m_p_reset_xsb_w = cq*(qint3-qint1)/4e-9*mean(v(vdd))
  let m_i_reset_xsb_first_a = cq*(qint2-qint1)/2e-9
  let m_i_reset_xsb_last_a = cq*(qint3-qint2)/2e-9
  let m_q_v = qout_rst
  print m_i_reset_xsb_a
  print m_p_reset_xsb_w
  print m_i_reset_xsb_first_a
  print m_i_reset_xsb_last_a
  print m_q_v
.endc
.end
