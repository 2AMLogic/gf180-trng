* trnoise-calibration @ tt_27c_3.30v -- GENERATED by sim/harness, do not edit
* corner=tt (all device families typical)
* temp=27.0 C  vdd=3.3 V  pdk=gf180mcuD@c6d73a35f524070e85faff4a6a9eef49553ebc2b

* ---- PVT parameters -------------------------------------------------
.param vdd_nom=3.3
.param vdd_val=3.3
.param temp_c=27.0
.param vn_rms=2.2361e-3
.param vn_dt=1e-11
.param vn_flick=5.4772e-5

* ---- gf180mcu models ------------------------------------------------
.include "/Users/rwalters/.volare/gf180mcuD/libs.tech/ngspice/design.ngspice"
.option seed=1
.lib "/Users/rwalters/.volare/gf180mcuD/libs.tech/ngspice/sm141064.ngspice" typical
.lib "/Users/rwalters/.volare/gf180mcuD/libs.tech/ngspice/sm141064.ngspice" bjt_typical
.lib "/Users/rwalters/.volare/gf180mcuD/libs.tech/ngspice/sm141064.ngspice" diode_typical
.lib "/Users/rwalters/.volare/gf180mcuD/libs.tech/ngspice/sm141064.ngspice" res_typical
.lib "/Users/rwalters/.volare/gf180mcuD/libs.tech/ngspice/sm141064.ngspice" moscap_typical
.lib "/Users/rwalters/.volare/gf180mcuD/libs.tech/ngspice/sm141064.ngspice" mimcap_typical

.temp 27.0

* ---- testbench ------------------------------------------------------
.include "/Users/rwalters/GitHub/gf180-trng/.loom/worktrees/issue-4/sim/tb/trnoise-calibration/tb_trnoise_cal.sp"

* ---- measurement ----------------------------------------------------
.control
set numdgt=10
set noaskquit
  tran 10p 4u
  linearize
  let n_all = length(v(o1))
  let n_skip = 100
  let m_rms_white_src = sqrt(mean(v(nw)[100,400000]*v(nw)[100,400000]))
  let m_rms_rc_159meg = sqrt(mean(v(o1)[100,400000]*v(o1)[100,400000]))
  let m_rms_rc_15meg = sqrt(mean(v(o2)[100,400000]*v(o2)[100,400000]))
  let m_rms_flicker_rc_159meg = sqrt(mean(v(o3)[100,400000]*v(o3)[100,400000]))
  let m_n_samples = n_all
  print m_rms_white_src
  print m_rms_rc_159meg
  print m_rms_rc_15meg
  print m_rms_flicker_rc_159meg
  print m_n_samples
.endc
.end
