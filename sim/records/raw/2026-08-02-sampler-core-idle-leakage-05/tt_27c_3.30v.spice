* sampler-core-idle-leakage @ tt_27c_3.30v -- GENERATED by sim/harness, do not edit
* corner=tt (all device families typical)
* temp=27.0 C  vdd=3.3 V  pdk=gf180mcuD@c6d73a35f524070e85faff4a6a9eef49553ebc2b

* ---- PVT parameters -------------------------------------------------
.param vdd_nom=3.3
.param vdd_val=3.3
.param temp_c=27.0

* ---- gf180mcu models ------------------------------------------------
.include "/Users/rwalters/.volare/gf180mcuD/libs.tech/ngspice/design.ngspice"
.lib "/Users/rwalters/.volare/gf180mcuD/libs.tech/ngspice/sm141064.ngspice" typical
.lib "/Users/rwalters/.volare/gf180mcuD/libs.tech/ngspice/sm141064.ngspice" bjt_typical
.lib "/Users/rwalters/.volare/gf180mcuD/libs.tech/ngspice/sm141064.ngspice" diode_typical
.lib "/Users/rwalters/.volare/gf180mcuD/libs.tech/ngspice/sm141064.ngspice" res_typical
.lib "/Users/rwalters/.volare/gf180mcuD/libs.tech/ngspice/sm141064.ngspice" moscap_typical
.lib "/Users/rwalters/.volare/gf180mcuD/libs.tech/ngspice/sm141064.ngspice" mimcap_typical

.temp 27.0

* ---- device under test (schematic-derived, design/netlist.py) -------
.include "/Users/rwalters/GitHub/gf180-trng/.loom/worktrees/issue-14/design/sampler_core.spice"

* ---- testbench ------------------------------------------------------
.include "/Users/rwalters/GitHub/gf180-trng/.loom/worktrees/issue-14/sim/tb/sampler-core-idle-leakage/tb_sampler_core_idle_leakage.sp"

* ---- measurement ----------------------------------------------------
.control
set numdgt=10
set noaskquit
  tran 200p 1u
  meas tran qax find v(qa) at=600n
  meas tran qa0 find v(qa) at=800n
  meas tran qa1 find v(qa) at=1u
  meas tran qbx find v(qb) at=600n
  meas tran qb0 find v(qb) at=800n
  meas tran qb1 find v(qb) at=1u
  meas tran vro1 find v(xduta.xdut.ro1) at=1u
  meas tran vro2 find v(xduta.xdut.ro2) at=1u
  meas tran vxo find v(xduta.xo) at=1u
  meas tran vn1 find v(xduta.xdut.xr1.n1) at=1u
  meas tran vn2 find v(xduta.xdut.xr1.n2) at=1u
  meas tran vrba find v(rba) at=1u
  meas tran vrva find v(rva) at=1u
  meas tran vrbb find v(rbb) at=1u
  meas tran vrvb find v(rvb) at=1u
  meas tran vsupm find v(vsup) at=1u
  let cq = 1e-9
  let twin = 2e-7
  let m_i_idle_clklo_a = -cq*(qa1-qa0)/twin
  let m_i_idle_clkhi_a = -cq*(qb1-qb0)/twin
  let m_p_idle_clklo_w = -cq*(qa1-qa0)/twin*vsupm
  let m_p_idle_clkhi_w = -cq*(qb1-qb0)/twin*vsupm
  let m_i_idle_clklo_prev_a = -cq*(qa0-qax)/twin
  let m_i_idle_clkhi_prev_a = -cq*(qb0-qbx)/twin
  let m_i_idle_worst_a = max(-cq*(qa1-qa0)/twin,-cq*(qb1-qb0)/twin)
  let m_p_idle_worst_w = max(-cq*(qa1-qa0)/twin,-cq*(qb1-qb0)/twin)*vsupm
  let m_v_ro1_v = vro1
  let m_v_ro2_v = vro2
  let m_v_xo_v = vxo
  let m_v_n1_v = vn1
  let m_v_n2_v = vn2
  let m_v_rawbit_clklo_v = vrba
  let m_v_rawvalid_clklo_v = vrva
  let m_v_rawbit_clkhi_v = vrbb
  let m_v_rawvalid_clkhi_v = vrvb
  let m_v_sup_v = vsupm
  print m_i_idle_clklo_a
  print m_i_idle_clkhi_a
  print m_p_idle_clklo_w
  print m_p_idle_clkhi_w
  print m_i_idle_clklo_prev_a
  print m_i_idle_clkhi_prev_a
  print m_i_idle_worst_a
  print m_p_idle_worst_w
  print m_v_ro1_v
  print m_v_ro2_v
  print m_v_xo_v
  print m_v_n1_v
  print m_v_n2_v
  print m_v_rawbit_clklo_v
  print m_v_rawvalid_clklo_v
  print m_v_rawbit_clkhi_v
  print m_v_rawvalid_clkhi_v
  print m_v_sup_v
.endc
.end
