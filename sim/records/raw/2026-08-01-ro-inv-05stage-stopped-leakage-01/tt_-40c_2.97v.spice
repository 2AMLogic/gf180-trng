* ro-inv-05stage-stopped-leakage @ tt_-40c_2.97v -- GENERATED by sim/harness, do not edit
* corner=tt (all device families typical)
* temp=-40.0 C  vdd=2.97 V  pdk=gf180mcuD@c6d73a35f524070e85faff4a6a9eef49553ebc2b

* ---- PVT parameters -------------------------------------------------
.param vdd_nom=3.3
.param vdd_val=2.97
.param temp_c=-40.0
.param en_val=0

* ---- gf180mcu models ------------------------------------------------
.include "/Users/rwalters/.volare/gf180mcuD/libs.tech/ngspice/design.ngspice"
.lib "/Users/rwalters/.volare/gf180mcuD/libs.tech/ngspice/sm141064.ngspice" typical
.lib "/Users/rwalters/.volare/gf180mcuD/libs.tech/ngspice/sm141064.ngspice" bjt_typical
.lib "/Users/rwalters/.volare/gf180mcuD/libs.tech/ngspice/sm141064.ngspice" diode_typical
.lib "/Users/rwalters/.volare/gf180mcuD/libs.tech/ngspice/sm141064.ngspice" res_typical
.lib "/Users/rwalters/.volare/gf180mcuD/libs.tech/ngspice/sm141064.ngspice" moscap_typical
.lib "/Users/rwalters/.volare/gf180mcuD/libs.tech/ngspice/sm141064.ngspice" mimcap_typical

.temp -40.0

* ---- testbench ------------------------------------------------------
.include "/Users/rwalters/GitHub/gf180-trng/.loom/worktrees/issue-32/sim/tb/ro-inv-05stage-stopped-leakage/tb_ro_inv_05stage_stopped.sp"

* ---- measurement ----------------------------------------------------
.control
set numdgt=10
set noaskquit
  op
  let m_i_leak_a = -i(vdd)
  let m_p_idle_w = -i(vdd)*v(vdd)
  let m_v_n1 = v(n1)
  let m_v_n2 = v(n2)
  let m_v_n3 = v(n3)
  let m_v_n4 = v(n4)
  let m_v_n5 = v(n5)
  let m_v_en = v(en)
  print m_i_leak_a
  print m_p_idle_w
  print m_v_n1
  print m_v_n2
  print m_v_n3
  print m_v_n4
  print m_v_n5
  print m_v_en
.endc
.end
