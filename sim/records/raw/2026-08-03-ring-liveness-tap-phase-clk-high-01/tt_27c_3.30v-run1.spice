* ring-liveness-tap-phase-clk-high @ tt_27c_3.30v -- GENERATED by sim/harness, do not edit
* corner=tt (all device families typical)
* temp=27.0 C  vdd=3.3 V  pdk=gf180mcuD@c6d73a35f524070e85faff4a6a9eef49553ebc2b

* ---- PVT parameters -------------------------------------------------
.param vdd_nom=3.3
.param vdd_val=3.3
.param temp_c=27.0
.param vn_rms=2.2361e-3
.param vn_dt=1e-11

* ---- gf180mcu models ------------------------------------------------
.include "/home/ubuntu/.volare/gf180mcuD/libs.tech/ngspice/design.ngspice"
.option seed=2
.lib "/home/ubuntu/.volare/gf180mcuD/libs.tech/ngspice/sm141064.ngspice" typical
.lib "/home/ubuntu/.volare/gf180mcuD/libs.tech/ngspice/sm141064.ngspice" bjt_typical
.lib "/home/ubuntu/.volare/gf180mcuD/libs.tech/ngspice/sm141064.ngspice" diode_typical
.lib "/home/ubuntu/.volare/gf180mcuD/libs.tech/ngspice/sm141064.ngspice" res_typical
.lib "/home/ubuntu/.volare/gf180mcuD/libs.tech/ngspice/sm141064.ngspice" moscap_typical
.lib "/home/ubuntu/.volare/gf180mcuD/libs.tech/ngspice/sm141064.ngspice" mimcap_typical

.temp 27.0

* ---- device under test (schematic-derived, design/netlist.py) -------
.include "/home/ubuntu/GitHub/gf180-trng/.loom/worktrees/issue-76/design/sampler_core.spice"

* ---- testbench ------------------------------------------------------
.include "/home/ubuntu/GitHub/gf180-trng/.loom/worktrees/issue-76/sim/tb/ring-liveness-tap-phase-clk-high/tb_ring_liveness_tap_phase_clk_high.sp"

* ---- measurement ----------------------------------------------------
.control
set numdgt=10
set noaskquit
  save x1 q1 vsup
  tran 1p 2.400003u
  let cq = 1e-9
  let nstg = 5
  let tc = vector(769)
  let k = 0
  while k < 769
    let ri = k + 2
    meas tran tk when v(x1)=0 rise=$&ri
    let tc[k] = tk
    let k = k + 1
  end
  meas tran qw0 find v(q1) when v(x1)=0 rise=258
  meas tran qw1 find v(q1) when v(x1)=0 rise=770
  let tbar = (tc[768] - tc[256])/512
  let tbars = (tc[16] - tc[0])/16
  let r1 = (tc[257,768] - tc[256,767]) - 1*tbar
  let r2 = (tc[258,768] - tc[256,766]) - 2*tbar
  let r4 = (tc[260,768] - tc[256,764]) - 4*tbar
  let r8 = (tc[264,768] - tc[256,760]) - 8*tbar
  let r16 = (tc[272,768] - tc[256,752]) - 16*tbar
  let r32 = (tc[288,768] - tc[256,736]) - 32*tbar
  let r64 = (tc[320,768] - tc[256,704]) - 64*tbar
  let r128 = (tc[384,768] - tc[256,640]) - 128*tbar
  let s1 = (tc[1,16] - tc[0,15]) - 1*tbars
  let s2 = (tc[2,16] - tc[0,14]) - 2*tbars
  let s4 = (tc[4,16] - tc[0,12]) - 4*tbars
  let s8 = (tc[8,16] - tc[0,8]) - 8*tbars
  let m_period = tbar
  let m_f_osc = 1/tbar
  let m_period_startup16 = tbars
  let m_period_b00 = (tc[48] - tc[0])/48
  let m_period_b01 = (tc[96] - tc[48])/48
  let m_period_b02 = (tc[144] - tc[96])/48
  let m_period_b03 = (tc[192] - tc[144])/48
  let m_period_b04 = (tc[240] - tc[192])/48
  let m_period_b05 = (tc[288] - tc[240])/48
  let m_period_b06 = (tc[336] - tc[288])/48
  let m_period_b07 = (tc[384] - tc[336])/48
  let m_period_b08 = (tc[432] - tc[384])/48
  let m_period_b09 = (tc[480] - tc[432])/48
  let m_period_b10 = (tc[528] - tc[480])/48
  let m_period_b11 = (tc[576] - tc[528])/48
  let m_period_b12 = (tc[624] - tc[576])/48
  let m_period_b13 = (tc[672] - tc[624])/48
  let m_period_b14 = (tc[720] - tc[672])/48
  let m_period_b15 = (tc[768] - tc[720])/48
  let m_sigma_1 = sqrt(mean(r1*r1)/(1 - 1/512))
  let m_sigma_2 = sqrt(mean(r2*r2)/(1 - 2/512))
  let m_sigma_4 = sqrt(mean(r4*r4)/(1 - 4/512))
  let m_sigma_8 = sqrt(mean(r8*r8)/(1 - 8/512))
  let m_sigma_16 = sqrt(mean(r16*r16)/(1 - 16/512))
  let m_sigma_32 = sqrt(mean(r32*r32)/(1 - 32/512))
  let m_sigma_64 = sqrt(mean(r64*r64)/(1 - 64/512))
  let m_sigma_128 = sqrt(mean(r128*r128)/(1 - 128/512))
  let m_sigma_startup16_1 = sqrt(mean(s1*s1)/(1 - 1/16))
  let m_sigma_startup16_2 = sqrt(mean(s2*s2)/(1 - 2/16))
  let m_sigma_startup16_4 = sqrt(mean(s4*s4)/(1 - 4/16))
  let m_sigma_startup16_8 = sqrt(mean(s8*s8)/(1 - 8/16))
  let m_i_ring_a = -cq*(qw1-qw0)/(tc[768]-tc[256])
  let m_p_active_w = -cq*(qw1-qw0)/(tc[768]-tc[256])*mean(v(vsup))
  let m_e_per_cycle_j = -cq*(qw1-qw0)/512*mean(v(vsup))
  let m_c_eff_node_f = -cq*(qw1-qw0)/(512*nstg*mean(v(vsup)))
  let m_vsup_v = mean(v(vsup))
  print m_period
  print m_f_osc
  print m_period_startup16
  print m_period_b00
  print m_period_b01
  print m_period_b02
  print m_period_b03
  print m_period_b04
  print m_period_b05
  print m_period_b06
  print m_period_b07
  print m_period_b08
  print m_period_b09
  print m_period_b10
  print m_period_b11
  print m_period_b12
  print m_period_b13
  print m_period_b14
  print m_period_b15
  print m_sigma_1
  print m_sigma_2
  print m_sigma_4
  print m_sigma_8
  print m_sigma_16
  print m_sigma_32
  print m_sigma_64
  print m_sigma_128
  print m_sigma_startup16_1
  print m_sigma_startup16_2
  print m_sigma_startup16_4
  print m_sigma_startup16_8
  print m_i_ring_a
  print m_p_active_w
  print m_e_per_cycle_j
  print m_c_eff_node_f
  print m_vsup_v
.endc
.end
