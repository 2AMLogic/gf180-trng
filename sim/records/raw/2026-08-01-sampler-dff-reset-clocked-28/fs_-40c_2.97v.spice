* sampler-dff-reset-clocked @ fs_-40c_2.97v -- GENERATED by sim/harness, do not edit
* corner=fs (fast NMOS / slow PMOS, passives typical)
* temp=-40.0 C  vdd=2.97 V  pdk=gf180mcuD@c6d73a35f524070e85faff4a6a9eef49553ebc2b

* ---- PVT parameters -------------------------------------------------
.param vdd_nom=3.3
.param vdd_val=2.97
.param temp_c=-40.0

* ---- gf180mcu models ------------------------------------------------
.include "/Users/rwalters/.volare/gf180mcuD/libs.tech/ngspice/design.ngspice"
.lib "/Users/rwalters/.volare/gf180mcuD/libs.tech/ngspice/sm141064.ngspice" fs
.lib "/Users/rwalters/.volare/gf180mcuD/libs.tech/ngspice/sm141064.ngspice" bjt_typical
.lib "/Users/rwalters/.volare/gf180mcuD/libs.tech/ngspice/sm141064.ngspice" diode_typical
.lib "/Users/rwalters/.volare/gf180mcuD/libs.tech/ngspice/sm141064.ngspice" res_typical
.lib "/Users/rwalters/.volare/gf180mcuD/libs.tech/ngspice/sm141064.ngspice" moscap_typical
.lib "/Users/rwalters/.volare/gf180mcuD/libs.tech/ngspice/sm141064.ngspice" mimcap_typical

.temp -40.0

* ---- device under test (schematic-derived, design/netlist.py) -------
.include "/Users/rwalters/GitHub/gf180-trng/.loom/worktrees/issue-53/design/sampler_core.spice"

* ---- testbench ------------------------------------------------------
.include "/Users/rwalters/GitHub/gf180-trng/.loom/worktrees/issue-53/sim/tb/sampler-dff-reset-clocked/tb_sampler_dff_reset_clocked.sp"

* ---- measurement ----------------------------------------------------
.control
set numdgt=10
set noaskquit
  tran 100p 6u
  meas tran q_rst_max max v(q) from=0.05u to=3.55u
  meas tran s_rst_min min v(xdut.s) from=0.05u to=3.55u
  meas tran q_rel find v(q) at=3.55u
  meas tran q_cap find v(q) at=4.9u
  meas tran mb_rst_min min v(xdut.mb) from=0.05u to=3.55u
  let vsup = mean(v(vdd))
  let m_q_rst_max_v = q_rst_max
  let m_q_rst_max_frac = q_rst_max/vsup
  let m_s_rst_min_v = s_rst_min
  let m_s_rst_dev_frac = (vsup-s_rst_min)/vsup
  let m_mb_rst_min_v = mb_rst_min
  let m_q_rel_v = q_rel
  let m_q_cap_v = q_cap
  print m_q_rst_max_v
  print m_q_rst_max_frac
  print m_s_rst_min_v
  print m_s_rst_dev_frac
  print m_mb_rst_min_v
  print m_q_rel_v
  print m_q_cap_v
.endc
.end
