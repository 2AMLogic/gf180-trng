* ro-array-core-power @ ff_-40c_3.63v -- GENERATED by sim/harness, do not edit
* corner=ff (all device families fast)
* temp=-40.0 C  vdd=3.63 V  pdk=gf180mcuD@c6d73a35f524070e85faff4a6a9eef49553ebc2b

* ---- PVT parameters -------------------------------------------------
.param vdd_nom=3.3
.param vdd_val=3.63
.param temp_c=-40.0

* ---- gf180mcu models ------------------------------------------------
.include "/home/ubuntu/.volare/gf180mcuD/libs.tech/ngspice/design.ngspice"
.lib "/home/ubuntu/.volare/gf180mcuD/libs.tech/ngspice/sm141064.ngspice" ff
.lib "/home/ubuntu/.volare/gf180mcuD/libs.tech/ngspice/sm141064.ngspice" bjt_ff
.lib "/home/ubuntu/.volare/gf180mcuD/libs.tech/ngspice/sm141064.ngspice" diode_ff
.lib "/home/ubuntu/.volare/gf180mcuD/libs.tech/ngspice/sm141064.ngspice" res_ff
.lib "/home/ubuntu/.volare/gf180mcuD/libs.tech/ngspice/sm141064.ngspice" moscap_ff
.lib "/home/ubuntu/.volare/gf180mcuD/libs.tech/ngspice/sm141064.ngspice" mimcap_ff

.temp -40.0

* ---- device under test (schematic-derived, design/netlist.py) -------
.include "/home/ubuntu/GitHub/gf180-trng/.loom/worktrees/issue-7/design/ro_array_core.spice"

* ---- testbench ------------------------------------------------------
.include "/home/ubuntu/GitHub/gf180-trng/.loom/worktrees/issue-7/sim/tb/ro-array-core-power/tb_ro_array_core_power.sp"

* ---- measurement ----------------------------------------------------
.control
set numdgt=10
set noaskquit
  tran 1p 60n
  meas tran t1a when v(xdut.ro1)=v(vth) rise=2
  meas tran t1b when v(xdut.ro1)=v(vth) rise=6
  meas tran t2a when v(xdut.ro2)=v(vth) rise=2
  meas tran t2b when v(xdut.ro2)=v(vth) rise=6
  meas tran t3a when v(xdut.ro3)=v(vth) rise=2
  meas tran t3b when v(xdut.ro3)=v(vth) rise=6
  meas tran t4a when v(xdut.ro4)=v(vth) rise=2
  meas tran t4b when v(xdut.ro4)=v(vth) rise=6
  meas tran c1a find v(q1) when v(xdut.ro1)=v(vth) rise=2
  meas tran c1b find v(q1) when v(xdut.ro1)=v(vth) rise=6
  meas tran c2a find v(q2) when v(xdut.ro2)=v(vth) rise=2
  meas tran c2b find v(q2) when v(xdut.ro2)=v(vth) rise=6
  meas tran c3a find v(q3) when v(xdut.ro3)=v(vth) rise=2
  meas tran c3b find v(q3) when v(xdut.ro3)=v(vth) rise=6
  meas tran c4a find v(q4) when v(xdut.ro4)=v(vth) rise=2
  meas tran c4b find v(q4) when v(xdut.ro4)=v(vth) rise=6
  meas tran cta find v(qt) when v(xdut.ro1)=v(vth) rise=2
  meas tran ctb find v(qt) when v(xdut.ro1)=v(vth) rise=6
  meas tran vhi max v(xdut.ro1) from=20n to=55n
  meas tran vlo min v(xdut.ro1) from=20n to=55n
  meas tran vxhi max v(xo) from=20n to=55n
  meas tran vxlo min v(xo) from=20n to=55n
  let cq = 1e-9
  let nper = 4
  let nstg = 11
  let m_period_r1 = (t1b-t1a)/nper
  let m_period_r2 = (t2b-t2a)/nper
  let m_period_r3 = (t3b-t3a)/nper
  let m_period_r4 = (t4b-t4a)/nper
  let m_f_r1 = nper/(t1b-t1a)
  let m_f_r2 = nper/(t2b-t2a)
  let m_f_r3 = nper/(t3b-t3a)
  let m_f_r4 = nper/(t4b-t4a)
  let m_i_r1_a = cq*(c1b-c1a)/(t1b-t1a)
  let m_i_r2_a = cq*(c2b-c2a)/(t2b-t2a)
  let m_i_r3_a = cq*(c3b-c3a)/(t3b-t3a)
  let m_i_r4_a = cq*(c4b-c4a)/(t4b-t4a)
  let m_i_tree_a = cq*(ctb-cta)/(t1b-t1a)
  let m_i_total_a = cq*((c1b-c1a)/(t1b-t1a)+(c2b-c2a)/(t2b-t2a)+(c3b-c3a)/(t3b-t3a)+(c4b-c4a)/(t4b-t4a)+(ctb-cta)/(t1b-t1a))
  let m_p_rings_w = cq*((c1b-c1a)/(t1b-t1a)+(c2b-c2a)/(t2b-t2a)+(c3b-c3a)/(t3b-t3a)+(c4b-c4a)/(t4b-t4a))*mean(v(vsup))
  let m_p_total_w = cq*((c1b-c1a)/(t1b-t1a)+(c2b-c2a)/(t2b-t2a)+(c3b-c3a)/(t3b-t3a)+(c4b-c4a)/(t4b-t4a)+(ctb-cta)/(t1b-t1a))*mean(v(vsup))
  let m_e_cycle_r1_j = cq*(c1b-c1a)/nper*mean(v(vsup))
  let m_e_cycle_r4_j = cq*(c4b-c4a)/nper*mean(v(vsup))
  let m_c_eff_node_r1_f = cq*(c1b-c1a)/(nper*nstg*mean(v(vsup)))
  let m_xo_trans_per_s = 2*(nper/(t1b-t1a)+nper/(t2b-t2a)+nper/(t3b-t3a)+nper/(t4b-t4a))
  let m_ring_swing_v = vhi-vlo
  let m_xo_swing_v = vxhi-vxlo
  print m_period_r1
  print m_period_r2
  print m_period_r3
  print m_period_r4
  print m_f_r1
  print m_f_r2
  print m_f_r3
  print m_f_r4
  print m_i_r1_a
  print m_i_r2_a
  print m_i_r3_a
  print m_i_r4_a
  print m_i_tree_a
  print m_i_total_a
  print m_p_rings_w
  print m_p_total_w
  print m_e_cycle_r1_j
  print m_e_cycle_r4_j
  print m_c_eff_node_r1_f
  print m_xo_trans_per_s
  print m_ring_swing_v
  print m_xo_swing_v
.endc
.end
