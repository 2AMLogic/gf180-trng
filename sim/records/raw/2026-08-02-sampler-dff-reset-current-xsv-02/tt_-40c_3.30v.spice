* sampler-dff-reset-current-xsv @ tt_-40c_3.30v -- GENERATED by sim/harness, do not edit
* corner=tt (all device families typical)
* temp=-40.0 C  vdd=3.3 V  pdk=gf180mcuD@c6d73a35f524070e85faff4a6a9eef49553ebc2b

* ---- PVT parameters -------------------------------------------------
.param vdd_nom=3.3
.param vdd_val=3.3
.param temp_c=-40.0

* ---- gf180mcu models ------------------------------------------------
.include "/Users/rwalters/.volare/gf180mcuD/libs.tech/ngspice/design.ngspice"
.lib "/Users/rwalters/.volare/gf180mcuD/libs.tech/ngspice/sm141064.ngspice" typical
.lib "/Users/rwalters/.volare/gf180mcuD/libs.tech/ngspice/sm141064.ngspice" bjt_typical
.lib "/Users/rwalters/.volare/gf180mcuD/libs.tech/ngspice/sm141064.ngspice" diode_typical
.lib "/Users/rwalters/.volare/gf180mcuD/libs.tech/ngspice/sm141064.ngspice" res_typical
.lib "/Users/rwalters/.volare/gf180mcuD/libs.tech/ngspice/sm141064.ngspice" moscap_typical
.lib "/Users/rwalters/.volare/gf180mcuD/libs.tech/ngspice/sm141064.ngspice" mimcap_typical

.temp -40.0

* ---- device under test (schematic-derived, design/netlist.py) -------
.include "/Users/rwalters/GitHub/gf180-trng/.loom/worktrees/issue-53/design/sampler_core.spice"

* ---- testbench ------------------------------------------------------
.include "/Users/rwalters/GitHub/gf180-trng/.loom/worktrees/issue-53/sim/tb/sampler-dff-reset-current-xsv/tb_sampler_dff_reset_current_xsv.sp"

* ---- measurement ----------------------------------------------------
.control
set numdgt=10
set noaskquit
  op
  let m_i_reset_xsv_a = -i(vdd)
  let m_p_reset_xsv_w = -i(vdd)*v(vdd)
  let m_v_q = v(q)
  let m_v_m = v(xdut.m)
  let m_v_mb = v(xdut.mb)
  let m_v_qb = v(xdut.qb)
  print m_i_reset_xsv_a
  print m_p_reset_xsv_w
  print m_v_q
  print m_v_m
  print m_v_mb
  print m_v_qb
.endc
.end
