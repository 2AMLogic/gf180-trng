* ro-array-core-mc-freq @ tt_27c_3.30v -- GENERATED by sim/harness, do not edit
* corner=tt (all device families typical)
* temp=27.0 C  vdd=3.3 V  pdk=gf180mcuD@c6d73a35f524070e85faff4a6a9eef49553ebc2b

* ---- PVT parameters -------------------------------------------------
.param vdd_nom=3.3
.param vdd_val=3.3
.param temp_c=27.0

* ---- gf180mcu models ------------------------------------------------
.include "/Users/rwalters/.volare/gf180mcuD/libs.tech/ngspice/design.ngspice"
.option seed=7
.param sw_stat_mismatch=1
.lib "/Users/rwalters/.volare/gf180mcuD/libs.tech/ngspice/sm141064.ngspice" statistical

.temp 27.0

* ---- device under test (schematic-derived, design/netlist.py) -------
.include "/Users/rwalters/GitHub/gf180-trng/.loom/worktrees/issue-13/design/ro_array_core.spice"

* ---- testbench ------------------------------------------------------
.include "/Users/rwalters/GitHub/gf180-trng/.loom/worktrees/issue-13/sim/tb/ro-array-core-mc-freq/tb_ro_array_core_mc_freq.sp"

* ---- measurement ----------------------------------------------------
.control
set numdgt=10
set noaskquit
  tran 1p 100n
  meas tran t1a when v(xdut.ro1)=v(vth) rise=2
  meas tran t1b when v(xdut.ro1)=v(vth) rise=6
  meas tran t2a when v(xdut.ro2)=v(vth) rise=2
  meas tran t2b when v(xdut.ro2)=v(vth) rise=6
  meas tran c1a find v(q1) when v(xdut.ro1)=v(vth) rise=2
  meas tran c1b find v(q1) when v(xdut.ro1)=v(vth) rise=6
  meas tran c2a find v(q2) when v(xdut.ro2)=v(vth) rise=2
  meas tran c2b find v(q2) when v(xdut.ro2)=v(vth) rise=6
  let cq = 1e-9
  let nper = 4
  let m_period_r1 = (t1b-t1a)/nper
  let m_period_r2 = (t2b-t2a)/nper
  let m_f_r1 = nper/(t1b-t1a)
  let m_f_r2 = nper/(t2b-t2a)
  let m_i_r1_a = cq*(c1b-c1a)/(t1b-t1a)
  let m_i_r2_a = cq*(c2b-c2a)/(t2b-t2a)
  print m_period_r1
  print m_period_r2
  print m_f_r1
  print m_f_r2
  print m_i_r1_a
  print m_i_r2_a
.endc
.end
