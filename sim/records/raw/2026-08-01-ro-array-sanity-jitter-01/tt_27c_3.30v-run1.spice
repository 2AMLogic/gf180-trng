* ro-array-sanity-jitter @ tt_27c_3.30v -- GENERATED by sim/harness, do not edit
* corner=tt (all device families typical)
* temp=27.0 C  vdd=3.3 V  pdk=gf180mcuD@c6d73a35f524070e85faff4a6a9eef49553ebc2b

* ---- PVT parameters -------------------------------------------------
.param vdd_nom=3.3
.param vdd_val=3.3
.param temp_c=27.0
.param vn_rms=2.2361e-3
.param vn_dt=1e-11

* ---- gf180mcu models ------------------------------------------------
.include "/home/ubuntu/.volare/gf180mcuD/libs.tech/ngspice/design.ngspice"
.option seed=2
.lib "/home/ubuntu/.volare/gf180mcuD/libs.tech/ngspice/sm141064.ngspice" typical
.lib "/home/ubuntu/.volare/gf180mcuD/libs.tech/ngspice/sm141064.ngspice" bjt_typical
.lib "/home/ubuntu/.volare/gf180mcuD/libs.tech/ngspice/sm141064.ngspice" diode_typical
.lib "/home/ubuntu/.volare/gf180mcuD/libs.tech/ngspice/sm141064.ngspice" res_typical
.lib "/home/ubuntu/.volare/gf180mcuD/libs.tech/ngspice/sm141064.ngspice" moscap_typical
.lib "/home/ubuntu/.volare/gf180mcuD/libs.tech/ngspice/sm141064.ngspice" mimcap_typical

.temp 27.0

* ---- device under test (schematic-derived, design/netlist.py) -------
.include "/home/ubuntu/GitHub/gf180-trng/.loom/worktrees/issue-7/design/ro_array_sanity.spice"

* ---- testbench ------------------------------------------------------
.include "/home/ubuntu/GitHub/gf180-trng/.loom/worktrees/issue-7/sim/tb/ro-array-sanity-jitter/tb_ro_array_sanity_jitter.sp"

* ---- measurement ----------------------------------------------------
.control
set numdgt=10
set noaskquit
  tran 1p 70n
  meas tran t1a when v(x1)=0 rise=2
  meas tran t1b when v(x1)=0 rise=18
  meas tran t2a when v(x2)=0 rise=2
  meas tran t2b when v(x2)=0 rise=18
  meas tran t3a when v(x3)=0 rise=2
  meas tran t3b when v(x3)=0 rise=18
  meas tran t4a when v(x4)=0 rise=2
  meas tran t4b when v(x4)=0 rise=18
  meas tran c1a find v(q1) when v(x1)=0 rise=2
  meas tran c1b find v(q1) when v(x1)=0 rise=18
  meas tran c4a find v(q4) when v(x4)=0 rise=2
  meas tran c4b find v(q4) when v(x4)=0 rise=18
  meas tran cta find v(qt) when v(x1)=0 rise=2
  meas tran ctb find v(qt) when v(x1)=0 rise=18
  meas tran vhi max v(ro1) from=30n to=65n
  meas tran vlo min v(ro1) from=30n to=65n
  meas tran vxhi max v(xo) from=30n to=65n
  meas tran vxlo min v(xo) from=30n to=65n
  let tc = vector(17)
  let k = 2
  while k <= 18
    meas tran tk when v(x1)=0 rise=$&k
    let tc[k-2] = tk
    let k = k + 1
  end
  let nper = 16
  let nstg = 5
  let cq = 1e-9
  let tbar = (tc[16] - tc[0])/16
  let r1 = (tc[1,16] - tc[0,15]) - 1*tbar
  let r2 = (tc[2,16] - tc[0,14]) - 2*tbar
  let r4 = (tc[4,16] - tc[0,12]) - 4*tbar
  let r8 = (tc[8,16] - tc[0,8]) - 8*tbar
  let m_period_r1 = tbar
  let m_period_r2 = (t2b-t2a)/nper
  let m_period_r3 = (t3b-t3a)/nper
  let m_period_r4 = (t4b-t4a)/nper
  let m_f_r1 = 1/tbar
  let m_f_r2 = nper/(t2b-t2a)
  let m_f_r3 = nper/(t3b-t3a)
  let m_f_r4 = nper/(t4b-t4a)
  let m_sigma_r1_1 = sqrt(mean(r1*r1)/(1 - 1/16))
  let m_sigma_r1_2 = sqrt(mean(r2*r2)/(1 - 2/16))
  let m_sigma_r1_4 = sqrt(mean(r4*r4)/(1 - 4/16))
  let m_sigma_r1_8 = sqrt(mean(r8*r8)/(1 - 8/16))
  let m_i_r1_a = cq*(c1b-c1a)/(t1b-t1a)
  let m_i_r4_a = cq*(c4b-c4a)/(t4b-t4a)
  let m_i_tree_a = cq*(ctb-cta)/(t1b-t1a)
  let m_e_cycle_r1_j = cq*(c1b-c1a)/nper*mean(v(vsup))
  let m_c_eff_node_r1_f = cq*(c1b-c1a)/(nper*nstg*mean(v(vsup)))
  let m_ring1_swing_v = vhi-vlo
  let m_xo_swing_v = vxhi-vxlo
  let m_xo_trans_per_s = 2*(1/tbar+nper/(t2b-t2a)+nper/(t3b-t3a)+nper/(t4b-t4a))
  print m_period_r1
  print m_period_r2
  print m_period_r3
  print m_period_r4
  print m_f_r1
  print m_f_r2
  print m_f_r3
  print m_f_r4
  print m_sigma_r1_1
  print m_sigma_r1_2
  print m_sigma_r1_4
  print m_sigma_r1_8
  print m_i_r1_a
  print m_i_r4_a
  print m_i_tree_a
  print m_e_cycle_r1_j
  print m_c_eff_node_r1_f
  print m_ring1_swing_v
  print m_xo_swing_v
  print m_xo_trans_per_s
.endc
.end
