* jitter-estimator-calibration @ tt_27c_3.30v -- GENERATED by sim/harness, do not edit
* corner=tt (all device families typical)
* temp=27.0 C  vdd=3.3 V  pdk=gf180mcuD@c6d73a35f524070e85faff4a6a9eef49553ebc2b

* ---- PVT parameters -------------------------------------------------
.param vdd_nom=3.3
.param vdd_val=3.3
.param temp_c=27.0
.param vn_rms=2.2361e-3
.param vn_dt=1e-11

* ---- gf180mcu models ------------------------------------------------
.include "/Users/rwalters/.volare/gf180mcuD/libs.tech/ngspice/design.ngspice"
.option seed=4
.lib "/Users/rwalters/.volare/gf180mcuD/libs.tech/ngspice/sm141064.ngspice" typical
.lib "/Users/rwalters/.volare/gf180mcuD/libs.tech/ngspice/sm141064.ngspice" bjt_typical
.lib "/Users/rwalters/.volare/gf180mcuD/libs.tech/ngspice/sm141064.ngspice" diode_typical
.lib "/Users/rwalters/.volare/gf180mcuD/libs.tech/ngspice/sm141064.ngspice" res_typical
.lib "/Users/rwalters/.volare/gf180mcuD/libs.tech/ngspice/sm141064.ngspice" moscap_typical
.lib "/Users/rwalters/.volare/gf180mcuD/libs.tech/ngspice/sm141064.ngspice" mimcap_typical

.temp 27.0

* ---- testbench ------------------------------------------------------
.include "/Users/rwalters/GitHub/gf180-trng/.loom/worktrees/issue-10/sim/tb/jitter-estimator-calibration/tb_jitter_estimator_cal.sp"

* ---- measurement ----------------------------------------------------
.control
set numdgt=10
set noaskquit
  tran 10p 4u
  linearize
  let bit_h100 = (v(nw) + 0) gt 0
  let bit_h050 = (v(nw) + 1.2185674704539796e-3) gt 0
  let bit_h010 = (v(nw) + 3.351393504430205e-3) gt 0
  let m_p1_h100 = mean(bit_h100[100,400000])
  let m_p1_h050 = mean(bit_h050[100,400000])
  let m_p1_h010 = mean(bit_h010[100,400000])
  let m_rms_check = sqrt(mean(v(nw)[100,400000]*v(nw)[100,400000]))
  let m_n_samples = length(v(nw))
  print m_p1_h100
  print m_p1_h050
  print m_p1_h010
  print m_rms_check
  print m_n_samples
.endc
.end
