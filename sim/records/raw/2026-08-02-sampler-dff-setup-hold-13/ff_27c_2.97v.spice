* sampler-dff-setup-hold @ ff_27c_2.97v -- GENERATED by sim/harness, do not edit
* corner=ff (all device families fast)
* temp=27.0 C  vdd=2.97 V  pdk=gf180mcuD@c6d73a35f524070e85faff4a6a9eef49553ebc2b

* ---- PVT parameters -------------------------------------------------
.param vdd_nom=3.3
.param vdd_val=2.97
.param temp_c=27.0

* ---- gf180mcu models ------------------------------------------------
.include "/Users/rwalters/.volare/gf180mcuD/libs.tech/ngspice/design.ngspice"
.lib "/Users/rwalters/.volare/gf180mcuD/libs.tech/ngspice/sm141064.ngspice" ff
.lib "/Users/rwalters/.volare/gf180mcuD/libs.tech/ngspice/sm141064.ngspice" bjt_ff
.lib "/Users/rwalters/.volare/gf180mcuD/libs.tech/ngspice/sm141064.ngspice" diode_ff
.lib "/Users/rwalters/.volare/gf180mcuD/libs.tech/ngspice/sm141064.ngspice" res_ff
.lib "/Users/rwalters/.volare/gf180mcuD/libs.tech/ngspice/sm141064.ngspice" moscap_ff
.lib "/Users/rwalters/.volare/gf180mcuD/libs.tech/ngspice/sm141064.ngspice" mimcap_ff

.temp 27.0

* ---- device under test (schematic-derived, design/netlist.py) -------
.include "/Users/rwalters/GitHub/gf180-trng/.loom/worktrees/issue-53/design/sampler_core.spice"

* ---- testbench ------------------------------------------------------
.include "/Users/rwalters/GitHub/gf180-trng/.loom/worktrees/issue-53/sim/tb/sampler-dff-setup-hold/tb_sampler_dff_setup_hold.sp"

* ---- measurement ----------------------------------------------------
.control
set numdgt=10
set noaskquit
  tran 100p 6.5u
  meas tran tclk1 when v(clk)=v(vth) rise=1
  meas tran tclk2 when v(clk)=v(vth) rise=2
  meas tran tq_r1 when v(q)=v(vth) rise=1
  meas tran tq_f1 when v(q)=v(vth) fall=1
  meas tran q_rst find v(q) at=0.05u
  meas tran q_e1 find v(q) at=0.4u
  meas tran q_e2 find v(q) at=1.4u
  meas tran q_e3a find v(q) at=2.301u
  meas tran q_e3b find v(q) at=2.31u
  meas tran q_e3c find v(q) at=2.4u
  meas tran q_e4 find v(q) at=3.4u
  meas tran q_e5a find v(q) at=4.301u
  meas tran q_e5b find v(q) at=4.31u
  meas tran q_e5c find v(q) at=4.4u
  meas tran q_e6 find v(q) at=5.4u
  meas tran q_e7a find v(q) at=6.301u
  meas tran q_e7b find v(q) at=6.31u
  meas tran q_e7c find v(q) at=6.4u
  let vhalf = mean(v(vth))
  let m_tpd_clk_q_rise_s = tq_r1-tclk1
  let m_tpd_clk_q_fall_s = tq_f1-tclk2
  let m_q_rst_v = q_rst
  let m_q_e1_v = q_e1
  let m_q_e2_v = q_e2
  let m_q_e4_v = q_e4
  let m_q_e3_1ns_v = q_e3a
  let m_q_e3_10ns_v = q_e3b
  let m_q_e3_100ns_v = q_e3c
  let m_q_e3_drift_v = q_e3c-q_e3a
  let m_q_e3_rail_dev_v = vhalf-abs(q_e3c-vhalf)
  let m_q_e5_1ns_v = q_e5a
  let m_q_e5_10ns_v = q_e5b
  let m_q_e5_100ns_v = q_e5c
  let m_q_e5_drift_v = q_e5c-q_e5a
  let m_q_e5_rail_dev_v = vhalf-abs(q_e5c-vhalf)
  let m_q_e6_v = q_e6
  let m_q_e7_1ns_v = q_e7a
  let m_q_e7_10ns_v = q_e7b
  let m_q_e7_100ns_v = q_e7c
  let m_q_e7_drift_v = q_e7c-q_e7a
  let m_q_e7_rail_dev_v = vhalf-abs(q_e7c-vhalf)
  print m_tpd_clk_q_rise_s
  print m_tpd_clk_q_fall_s
  print m_q_rst_v
  print m_q_e1_v
  print m_q_e2_v
  print m_q_e4_v
  print m_q_e3_1ns_v
  print m_q_e3_10ns_v
  print m_q_e3_100ns_v
  print m_q_e3_drift_v
  print m_q_e3_rail_dev_v
  print m_q_e5_1ns_v
  print m_q_e5_10ns_v
  print m_q_e5_100ns_v
  print m_q_e5_drift_v
  print m_q_e5_rail_dev_v
  print m_q_e6_v
  print m_q_e7_1ns_v
  print m_q_e7_10ns_v
  print m_q_e7_100ns_v
  print m_q_e7_drift_v
  print m_q_e7_rail_dev_v
.endc
.end
