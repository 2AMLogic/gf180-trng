* ro-array-core-startup @ tt_-40c_2.97v -- GENERATED by sim/harness, do not edit
* corner=tt (all device families typical)
* temp=-40.0 C  vdd=2.97 V  pdk=gf180mcuD@c6d73a35f524070e85faff4a6a9eef49553ebc2b

* ---- PVT parameters -------------------------------------------------
.param vdd_nom=3.3
.param vdd_val=2.97
.param temp_c=-40.0

* ---- gf180mcu models ------------------------------------------------
.include "/Users/rwalters/.volare/gf180mcuD/libs.tech/ngspice/design.ngspice"
.lib "/Users/rwalters/.volare/gf180mcuD/libs.tech/ngspice/sm141064.ngspice" typical
.lib "/Users/rwalters/.volare/gf180mcuD/libs.tech/ngspice/sm141064.ngspice" bjt_typical
.lib "/Users/rwalters/.volare/gf180mcuD/libs.tech/ngspice/sm141064.ngspice" diode_typical
.lib "/Users/rwalters/.volare/gf180mcuD/libs.tech/ngspice/sm141064.ngspice" res_typical
.lib "/Users/rwalters/.volare/gf180mcuD/libs.tech/ngspice/sm141064.ngspice" moscap_typical
.lib "/Users/rwalters/.volare/gf180mcuD/libs.tech/ngspice/sm141064.ngspice" mimcap_typical

.temp -40.0

* ---- device under test (schematic-derived, design/netlist.py) -------
.include "/Users/rwalters/GitHub/gf180-trng/.loom/worktrees/issue-14/design/ro_array_core.spice"

* ---- testbench ------------------------------------------------------
.include "/Users/rwalters/GitHub/gf180-trng/.loom/worktrees/issue-14/sim/tb/ro-array-core-startup/tb_ro_array_core_startup.sp"

* ---- measurement ----------------------------------------------------
.control
set numdgt=10
set noaskquit
  tran 2p 180n
  meas tran t1r1 when v(xdut.ro1)=v(vth) rise=1
  meas tran t2r1 when v(xdut.ro1)=v(vth) rise=2
  meas tran t3r1 when v(xdut.ro1)=v(vth) rise=3
  meas tran t4r1 when v(xdut.ro1)=v(vth) rise=4
  meas tran t5r1 when v(xdut.ro1)=v(vth) rise=5
  meas tran t6r1 when v(xdut.ro1)=v(vth) rise=6
  meas tran t7r1 when v(xdut.ro1)=v(vth) rise=7
  meas tran t8r1 when v(xdut.ro1)=v(vth) rise=8
  meas tran t9r1 when v(xdut.ro1)=v(vth) rise=9
  meas tran t10r1 when v(xdut.ro1)=v(vth) rise=10
  meas tran t1r2 when v(xdut.ro2)=v(vth) rise=1
  meas tran t2r2 when v(xdut.ro2)=v(vth) rise=2
  meas tran t3r2 when v(xdut.ro2)=v(vth) rise=3
  meas tran t4r2 when v(xdut.ro2)=v(vth) rise=4
  meas tran t5r2 when v(xdut.ro2)=v(vth) rise=5
  meas tran t6r2 when v(xdut.ro2)=v(vth) rise=6
  meas tran t7r2 when v(xdut.ro2)=v(vth) rise=7
  meas tran t8r2 when v(xdut.ro2)=v(vth) rise=8
  meas tran t9r2 when v(xdut.ro2)=v(vth) rise=9
  meas tran t10r2 when v(xdut.ro2)=v(vth) rise=10
  meas tran t1xo when v(xo)=v(vth) rise=1
  meas tran t2xo when v(xo)=v(vth) rise=2
  meas tran t3xo when v(xo)=v(vth) rise=3
  meas tran t4xo when v(xo)=v(vth) rise=4
  meas tran vhi_early max v(xdut.ro1) from=20n to=50n
  meas tran vlo_early min v(xdut.ro1) from=20n to=50n
  meas tran vhi_late max v(xdut.ro1) from=150n to=180n
  meas tran vlo_late min v(xdut.ro1) from=150n to=180n
  meas tran vxhi_early max v(xo) from=20n to=50n
  meas tran vxlo_early min v(xo) from=20n to=50n
  meas tran vxhi_late max v(xo) from=150n to=180n
  meas tran vxlo_late min v(xo) from=150n to=180n
  meas tran v_off_ro1 find v(xdut.ro1) at=4n
  meas tran v_off_xo find v(xo) at=4n
  let ten = 5e-9
  let m_en_assert_s = ten
  let m_t1r1_s = t1r1
  let m_t2r1_s = t2r1
  let m_t3r1_s = t3r1
  let m_t4r1_s = t4r1
  let m_t5r1_s = t5r1
  let m_t6r1_s = t6r1
  let m_t7r1_s = t7r1
  let m_t8r1_s = t8r1
  let m_t9r1_s = t9r1
  let m_t10r1_s = t10r1
  let m_t1r2_s = t1r2
  let m_t2r2_s = t2r2
  let m_t3r2_s = t3r2
  let m_t4r2_s = t4r2
  let m_t5r2_s = t5r2
  let m_t6r2_s = t6r2
  let m_t7r2_s = t7r2
  let m_t8r2_s = t8r2
  let m_t9r2_s = t9r2
  let m_t10r2_s = t10r2
  let m_t1xo_s = t1xo
  let m_t2xo_s = t2xo
  let m_t3xo_s = t3xo
  let m_t4xo_s = t4xo
  let m_ring_swing_early_v = vhi_early-vlo_early
  let m_ring_swing_late_v = vhi_late-vlo_late
  let m_xo_swing_early_v = vxhi_early-vxlo_early
  let m_xo_swing_late_v = vxhi_late-vxlo_late
  let m_v_ro1_off_v = v_off_ro1
  let m_v_xo_off_v = v_off_xo
  print m_en_assert_s
  print m_t1r1_s
  print m_t2r1_s
  print m_t3r1_s
  print m_t4r1_s
  print m_t5r1_s
  print m_t6r1_s
  print m_t7r1_s
  print m_t8r1_s
  print m_t9r1_s
  print m_t10r1_s
  print m_t1r2_s
  print m_t2r2_s
  print m_t3r2_s
  print m_t4r2_s
  print m_t5r2_s
  print m_t6r2_s
  print m_t7r2_s
  print m_t8r2_s
  print m_t9r2_s
  print m_t10r2_s
  print m_t1xo_s
  print m_t2xo_s
  print m_t3xo_s
  print m_t4xo_s
  print m_ring_swing_early_v
  print m_ring_swing_late_v
  print m_xo_swing_early_v
  print m_xo_swing_late_v
  print m_v_ro1_off_v
  print m_v_xo_off_v
.endc
.end
