* array-liveness-tap-phase-clocked @ tt_27c_3.30v -- GENERATED by sim/harness, do not edit
* corner=tt (all device families typical)
* temp=27.0 C  vdd=3.3 V  pdk=gf180mcuD@c6d73a35f524070e85faff4a6a9eef49553ebc2b

* ---- PVT parameters -------------------------------------------------
.param vdd_nom=3.3
.param vdd_val=3.3
.param temp_c=27.0
.param vn_rms=2.2361e-3
.param vn_dt=1e-11
.param tclk_per=1.0007u
.param tclk_tr=0.203n
.param tclk_del=5.003n

* ---- gf180mcu models ------------------------------------------------
.include "/Users/rwalters/.volare/gf180mcuD/libs.tech/ngspice/design.ngspice"
.option seed=3
.lib "/Users/rwalters/.volare/gf180mcuD/libs.tech/ngspice/sm141064.ngspice" typical
.lib "/Users/rwalters/.volare/gf180mcuD/libs.tech/ngspice/sm141064.ngspice" bjt_typical
.lib "/Users/rwalters/.volare/gf180mcuD/libs.tech/ngspice/sm141064.ngspice" diode_typical
.lib "/Users/rwalters/.volare/gf180mcuD/libs.tech/ngspice/sm141064.ngspice" res_typical
.lib "/Users/rwalters/.volare/gf180mcuD/libs.tech/ngspice/sm141064.ngspice" moscap_typical
.lib "/Users/rwalters/.volare/gf180mcuD/libs.tech/ngspice/sm141064.ngspice" mimcap_typical

.temp 27.0

* ---- device under test (schematic-derived, design/netlist.py) -------
.include "/Users/rwalters/loom-scratch/gf180-trng-issue87-tapphase/design/sampler_core.spice"

* ---- testbench ------------------------------------------------------
.include "/Users/rwalters/loom-scratch/gf180-trng-issue87-tapphase/sim/tb/array-liveness-tap-phase-clocked/tb_array_liveness_tap_phase_clocked.sp"

* ---- measurement ----------------------------------------------------
.control
set numdgt=10
set noaskquit
  save x1 x2 q1 q2 vsup
  tran 1p 3.000003u
  let cq = 1e-9
  let nstg = 11
  let tc = vector(385)
  let k = 0
  while k < 385
    let ri = k + 2
    meas tran tk when v(x1)=0 rise=$&ri
    let tc[k] = tk
    let k = k + 1
  end
  let tc2 = vector(385)
  let k2 = 0
  while k2 < 385
    let ri2 = k2 + 2
    meas tran tk2 when v(x2)=0 rise=$&ri2
    let tc2[k2] = tk2
    let k2 = k2 + 1
  end
  meas tran qw0 find v(q1) when v(x1)=0 rise=130
  meas tran qw1 find v(q1) when v(x1)=0 rise=386
  let tbar = (tc[384] - tc[128])/256
  let tbars = (tc[16] - tc[0])/16
  let tbar2 = (tc2[384] - tc2[128])/256
  let r1 = (tc[129,384] - tc[128,383]) - 1*tbar
  let r2 = (tc[130,384] - tc[128,382]) - 2*tbar
  let r4 = (tc[132,384] - tc[128,380]) - 4*tbar
  let r8 = (tc[136,384] - tc[128,376]) - 8*tbar
  let r16 = (tc[144,384] - tc[128,368]) - 16*tbar
  let r32 = (tc[160,384] - tc[128,352]) - 32*tbar
  let r64 = (tc[192,384] - tc[128,320]) - 64*tbar
  let u1 = (tc2[129,384] - tc2[128,383]) - 1*tbar2
  let u2 = (tc2[130,384] - tc2[128,382]) - 2*tbar2
  let u4 = (tc2[132,384] - tc2[128,380]) - 4*tbar2
  let u8 = (tc2[136,384] - tc2[128,376]) - 8*tbar2
  let u16 = (tc2[144,384] - tc2[128,368]) - 16*tbar2
  let u32 = (tc2[160,384] - tc2[128,352]) - 32*tbar2
  let u64 = (tc2[192,384] - tc2[128,320]) - 64*tbar2
  let s1 = (tc[1,16] - tc[0,15]) - 1*tbars
  let s2 = (tc[2,16] - tc[0,14]) - 2*tbars
  let s4 = (tc[4,16] - tc[0,12]) - 4*tbars
  let s8 = (tc[8,16] - tc[0,8]) - 8*tbars
  let m_period = tbar
  let m_f_osc = 1/tbar
  let m_period_startup16 = tbars
  let m_period_r2 = tbar2
  let m_period_b00 = (tc[24] - tc[0])/24
  let m_period_b01 = (tc[48] - tc[24])/24
  let m_period_b02 = (tc[72] - tc[48])/24
  let m_period_b03 = (tc[96] - tc[72])/24
  let m_period_b04 = (tc[120] - tc[96])/24
  let m_period_b05 = (tc[144] - tc[120])/24
  let m_period_b06 = (tc[168] - tc[144])/24
  let m_period_b07 = (tc[192] - tc[168])/24
  let m_period_b08 = (tc[216] - tc[192])/24
  let m_period_b09 = (tc[240] - tc[216])/24
  let m_period_b10 = (tc[264] - tc[240])/24
  let m_period_b11 = (tc[288] - tc[264])/24
  let m_period_b12 = (tc[312] - tc[288])/24
  let m_period_b13 = (tc[336] - tc[312])/24
  let m_period_b14 = (tc[360] - tc[336])/24
  let m_period_b15 = (tc[384] - tc[360])/24
  let m_sigma_1 = sqrt(mean(r1*r1)/(1 - 1/256))
  let m_sigma_2 = sqrt(mean(r2*r2)/(1 - 2/256))
  let m_sigma_4 = sqrt(mean(r4*r4)/(1 - 4/256))
  let m_sigma_8 = sqrt(mean(r8*r8)/(1 - 8/256))
  let m_sigma_16 = sqrt(mean(r16*r16)/(1 - 16/256))
  let m_sigma_32 = sqrt(mean(r32*r32)/(1 - 32/256))
  let m_sigma_64 = sqrt(mean(r64*r64)/(1 - 64/256))
  let m_sigma_r2_1 = sqrt(mean(u1*u1)/(1 - 1/256))
  let m_sigma_r2_2 = sqrt(mean(u2*u2)/(1 - 2/256))
  let m_sigma_r2_4 = sqrt(mean(u4*u4)/(1 - 4/256))
  let m_sigma_r2_8 = sqrt(mean(u8*u8)/(1 - 8/256))
  let m_sigma_r2_16 = sqrt(mean(u16*u16)/(1 - 16/256))
  let m_sigma_r2_32 = sqrt(mean(u32*u32)/(1 - 32/256))
  let m_sigma_r2_64 = sqrt(mean(u64*u64)/(1 - 64/256))
  let m_sigma_startup16_1 = sqrt(mean(s1*s1)/(1 - 1/16))
  let m_sigma_startup16_2 = sqrt(mean(s2*s2)/(1 - 2/16))
  let m_sigma_startup16_4 = sqrt(mean(s4*s4)/(1 - 4/16))
  let m_sigma_startup16_8 = sqrt(mean(s8*s8)/(1 - 8/16))
  let m_i_ring_a = -cq*(qw1-qw0)/(tc[384]-tc[128])
  let m_p_active_w = -cq*(qw1-qw0)/(tc[384]-tc[128])*mean(v(vsup))
  let m_e_per_cycle_j = -cq*(qw1-qw0)/256*mean(v(vsup))
  let m_c_eff_node_f = -cq*(qw1-qw0)/(256*nstg*mean(v(vsup)))
  let m_vsup_v = mean(v(vsup))
  print m_period
  print m_f_osc
  print m_period_startup16
  print m_period_r2
  print m_period_b00
  print m_period_b01
  print m_period_b02
  print m_period_b03
  print m_period_b04
  print m_period_b05
  print m_period_b06
  print m_period_b07
  print m_period_b08
  print m_period_b09
  print m_period_b10
  print m_period_b11
  print m_period_b12
  print m_period_b13
  print m_period_b14
  print m_period_b15
  print m_sigma_1
  print m_sigma_2
  print m_sigma_4
  print m_sigma_8
  print m_sigma_16
  print m_sigma_32
  print m_sigma_64
  print m_sigma_r2_1
  print m_sigma_r2_2
  print m_sigma_r2_4
  print m_sigma_r2_8
  print m_sigma_r2_16
  print m_sigma_r2_32
  print m_sigma_r2_64
  print m_sigma_startup16_1
  print m_sigma_startup16_2
  print m_sigma_startup16_4
  print m_sigma_startup16_8
  print m_i_ring_a
  print m_p_active_w
  print m_e_per_cycle_j
  print m_c_eff_node_f
  print m_vsup_v
.endc
.end
