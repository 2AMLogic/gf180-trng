* sampler-bit-bias-static-generic @ tt_27c_3.30v -- GENERATED by sim/harness, do not edit
* corner=tt (all device families typical)
* temp=27.0 C  vdd=3.3 V  pdk=gf180mcuD@c6d73a35f524070e85faff4a6a9eef49553ebc2b

* ---- PVT parameters -------------------------------------------------
.param vdd_nom=3.3
.param vdd_val=3.3
.param temp_c=27.0
.param vn_rms=7.0713e-4
.param vn_dt=1e-10
.param tclk_per=12.46n
.param tclk_tr=0.203n
.param tclk_del=300.003n

* ---- gf180mcu models ------------------------------------------------
.include "/Users/rwalters/.volare/gf180mcuD/libs.tech/ngspice/design.ngspice"
.option seed=3
.lib "/Users/rwalters/.volare/gf180mcuD/libs.tech/ngspice/sm141064.ngspice" typical
.lib "/Users/rwalters/.volare/gf180mcuD/libs.tech/ngspice/sm141064.ngspice" bjt_typical
.lib "/Users/rwalters/.volare/gf180mcuD/libs.tech/ngspice/sm141064.ngspice" diode_typical
.lib "/Users/rwalters/.volare/gf180mcuD/libs.tech/ngspice/sm141064.ngspice" res_typical
.lib "/Users/rwalters/.volare/gf180mcuD/libs.tech/ngspice/sm141064.ngspice" moscap_typical
.lib "/Users/rwalters/.volare/gf180mcuD/libs.tech/ngspice/sm141064.ngspice" mimcap_typical

.temp 27.0
.options abstol=1e-10

* ---- device under test (schematic-derived, design/netlist.py) -------
.include "/Users/rwalters/GitHub/gf180-trng/.loom/worktrees/issue-86/design/sampler_core.spice"

* ---- testbench ------------------------------------------------------
.include "/Users/rwalters/GitHub/gf180-trng/.loom/worktrees/issue-86/sim/tb/sampler-bit-bias-static-generic/tb_sampler_bit_bias_static.sp"

* ---- measurement ----------------------------------------------------
.control
set numdgt=10
set noaskquit
  save raw_bit x1 x2 xc xo vth tclkv
  tran 20p 3600.003000n
  meas tran t1a when v(x1)=0 rise=200
  meas tran t1b when v(x1)=0 rise=1000
  meas tran t2a when v(x2)=0 rise=200
  meas tran t2b when v(x2)=0 rise=1000
  meas tran vxhi max v(xo) from=400n to=3500n
  meas tran vxlo min v(xo) from=400n to=3500n
  let nper = 800
  let bits = vector(256)
  let k = 0
  while k < 256
    let ri = k + 4
    meas tran bk find v(raw_bit) when v(xc)=0 fall=$&ri
    let bits[k] = bk
    let k = k + 1
  end
  let vhalf = mean(v(vth))
  let bg = bits gt vhalf
  let sb = 2*bg - 1
  let railerr = vhalf - abs(bits - vhalf)
  let pw = vector(16)
  let j = 0
  while j < 16
    let pw[j] = 2^j
    let j = j + 1
  end
  let m_period_r1 = (t1b-t1a)/nper
  let m_period_r2 = (t2b-t2a)/nper
  let m_f_r1 = nper/(t1b-t1a)
  let m_f_r2 = nper/(t2b-t2a)
  let m_ring1_periods_per_sample = mean(v(tclkv))*nper/(t1b-t1a)
  let m_ring2_periods_per_sample = mean(v(tclkv))*nper/(t2b-t2a)
  let m_tclk_s = mean(v(tclkv))
  let m_n_samples = 256
  let m_ones_frac = mean(bg)
  let m_bit_mean = mean(sb)
  let m_ones_frac_first128 = mean(bg[0,127])
  let m_ones_frac_last128 = mean(bg[128,255])
  let m_worst_rail_dev_v = vecmax(railerr)
  let m_xo_swing_v = vxhi-vxlo
  let m_r_1 = mean(sb[0,254]*sb[1,255])
  let m_r_2 = mean(sb[0,253]*sb[2,255])
  let m_r_3 = mean(sb[0,252]*sb[3,255])
  let m_r_4 = mean(sb[0,251]*sb[4,255])
  let m_r_6 = mean(sb[0,249]*sb[6,255])
  let m_r_8 = mean(sb[0,247]*sb[8,255])
  let m_r_12 = mean(sb[0,243]*sb[12,255])
  let m_r_16 = mean(sb[0,239]*sb[16,255])
  let m_bit_code_00 = 16*mean(bg[0,15]*pw)
  let m_bit_code_01 = 16*mean(bg[16,31]*pw)
  let m_bit_code_02 = 16*mean(bg[32,47]*pw)
  let m_bit_code_03 = 16*mean(bg[48,63]*pw)
  let m_bit_code_04 = 16*mean(bg[64,79]*pw)
  let m_bit_code_05 = 16*mean(bg[80,95]*pw)
  let m_bit_code_06 = 16*mean(bg[96,111]*pw)
  let m_bit_code_07 = 16*mean(bg[112,127]*pw)
  let m_bit_code_08 = 16*mean(bg[128,143]*pw)
  let m_bit_code_09 = 16*mean(bg[144,159]*pw)
  let m_bit_code_10 = 16*mean(bg[160,175]*pw)
  let m_bit_code_11 = 16*mean(bg[176,191]*pw)
  let m_bit_code_12 = 16*mean(bg[192,207]*pw)
  let m_bit_code_13 = 16*mean(bg[208,223]*pw)
  let m_bit_code_14 = 16*mean(bg[224,239]*pw)
  let m_bit_code_15 = 16*mean(bg[240,255]*pw)
  print m_period_r1
  print m_period_r2
  print m_f_r1
  print m_f_r2
  print m_ring1_periods_per_sample
  print m_ring2_periods_per_sample
  print m_tclk_s
  print m_n_samples
  print m_ones_frac
  print m_bit_mean
  print m_ones_frac_first128
  print m_ones_frac_last128
  print m_worst_rail_dev_v
  print m_xo_swing_v
  print m_r_1
  print m_r_2
  print m_r_3
  print m_r_4
  print m_r_6
  print m_r_8
  print m_r_12
  print m_r_16
  print m_bit_code_00
  print m_bit_code_01
  print m_bit_code_02
  print m_bit_code_03
  print m_bit_code_04
  print m_bit_code_05
  print m_bit_code_06
  print m_bit_code_07
  print m_bit_code_08
  print m_bit_code_09
  print m_bit_code_10
  print m_bit_code_11
  print m_bit_code_12
  print m_bit_code_13
  print m_bit_code_14
  print m_bit_code_15
.endc
.end
