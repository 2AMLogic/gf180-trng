* sampler-array-digitize @ ss_-40c_3.63v -- GENERATED by sim/harness, do not edit
* corner=ss (all device families slow)
* temp=-40.0 C  vdd=3.63 V  pdk=gf180mcuD@c6d73a35f524070e85faff4a6a9eef49553ebc2b

* ---- PVT parameters -------------------------------------------------
.param vdd_nom=3.3
.param vdd_val=3.63
.param temp_c=-40.0
.param vn_rms=2.2361e-3
.param vn_dt=1e-11
.param tclk=10e-9
.param tclk0=30e-9
.param tclk_tr=1e-9

* ---- gf180mcu models ------------------------------------------------
.include "/Users/rwalters/.volare/gf180mcuD/libs.tech/ngspice/design.ngspice"
.option seed=1001
.lib "/Users/rwalters/.volare/gf180mcuD/libs.tech/ngspice/sm141064.ngspice" ss
.lib "/Users/rwalters/.volare/gf180mcuD/libs.tech/ngspice/sm141064.ngspice" bjt_ss
.lib "/Users/rwalters/.volare/gf180mcuD/libs.tech/ngspice/sm141064.ngspice" diode_ss
.lib "/Users/rwalters/.volare/gf180mcuD/libs.tech/ngspice/sm141064.ngspice" res_ss
.lib "/Users/rwalters/.volare/gf180mcuD/libs.tech/ngspice/sm141064.ngspice" moscap_ss
.lib "/Users/rwalters/.volare/gf180mcuD/libs.tech/ngspice/sm141064.ngspice" mimcap_ss

.temp -40.0
.options abstol=1e-10

* ---- device under test (schematic-derived, design/netlist.py) -------
.include "/Users/rwalters/GitHub/gf180-trng/.loom/worktrees/issue-53/design/sampler_core.spice"

* ---- testbench ------------------------------------------------------
.include "/Users/rwalters/GitHub/gf180-trng/.loom/worktrees/issue-53/sim/tb/sampler-array-digitize/tb_sampler_array_digitize.sp"

* ---- measurement ----------------------------------------------------
.control
set numdgt=10
set noaskquit
  tran 10p 132n
  meas tran rb_rst find v(raw_bit) at=25n
  meas tran rv_rst find v(raw_valid) at=25n
  meas tran b0 find v(raw_bit) at=39n
  meas tran b1 find v(raw_bit) at=49n
  meas tran b2 find v(raw_bit) at=59n
  meas tran b3 find v(raw_bit) at=69n
  meas tran b4 find v(raw_bit) at=79n
  meas tran b5 find v(raw_bit) at=89n
  meas tran b6 find v(raw_bit) at=99n
  meas tran b7 find v(raw_bit) at=109n
  meas tran b8 find v(raw_bit) at=119n
  meas tran b9 find v(raw_bit) at=129n
  meas tran v0 find v(raw_valid) at=39n
  meas tran v9 find v(raw_valid) at=129n
  meas tran t1a when v(x1)=0 rise=2
  meas tran t1b when v(x1)=0 rise=14
  meas tran t2a when v(x2)=0 rise=2
  meas tran t2b when v(x2)=0 rise=14
  meas tran vxhi max v(xo) from=30n to=130n
  meas tran vxlo min v(xo) from=30n to=130n
  meas tran vrhi max v(ro1) from=30n to=130n
  meas tran vrlo min v(ro1) from=30n to=130n
  let nper = 12
  let bits = vector(10)
  let bits[0] = b0
  let bits[1] = b1
  let bits[2] = b2
  let bits[3] = b3
  let bits[4] = b4
  let bits[5] = b5
  let bits[6] = b6
  let bits[7] = b7
  let bits[8] = b8
  let bits[9] = b9
  let vhalf = mean(v(vth))
  let level = bits - vhalf
  let railerr = vhalf - abs(level)
  let m_rb_rst_v = rb_rst
  let m_rv_rst_v = rv_rst
  let m_b0_v = b0
  let m_b1_v = b1
  let m_b2_v = b2
  let m_b3_v = b3
  let m_b4_v = b4
  let m_b5_v = b5
  let m_b6_v = b6
  let m_b7_v = b7
  let m_b8_v = b8
  let m_b9_v = b9
  let m_rv0_v = v0
  let m_rv9_v = v9
  let m_ones_count = mean(level gt 0)*10
  let m_worst_rail_dev_v = vecmax(railerr)
  let m_period_r1 = (t1b-t1a)/nper
  let m_period_r2 = (t2b-t2a)/nper
  let m_f_r1 = nper/(t1b-t1a)
  let m_f_r2 = nper/(t2b-t2a)
  let m_freq_ratio_r2_r1 = (t1b-t1a)/(t2b-t2a)
  let m_ring_periods_per_sample = mean(v(tclkv))*nper/(t1b-t1a)
  let m_xo_swing_v = vxhi-vxlo
  let m_ring1_swing_v = vrhi-vrlo
  let m_xo_trans_per_s = 2*(nper/(t1b-t1a)+nper/(t2b-t2a))
  print m_rb_rst_v
  print m_rv_rst_v
  print m_b0_v
  print m_b1_v
  print m_b2_v
  print m_b3_v
  print m_b4_v
  print m_b5_v
  print m_b6_v
  print m_b7_v
  print m_b8_v
  print m_b9_v
  print m_rv0_v
  print m_rv9_v
  print m_ones_count
  print m_worst_rail_dev_v
  print m_period_r1
  print m_period_r2
  print m_f_r1
  print m_f_r2
  print m_freq_ratio_r2_r1
  print m_ring_periods_per_sample
  print m_xo_swing_v
  print m_ring1_swing_v
  print m_xo_trans_per_s
.endc
.end
