* inv-stage-noise @ ss_125c_3.30v -- GENERATED by sim/harness, do not edit
* corner=ss (all device families slow)
* temp=125.0 C  vdd=3.3 V  pdk=gf180mcuD@c6d73a35f524070e85faff4a6a9eef49553ebc2b

* ---- PVT parameters -------------------------------------------------
.param vdd_nom=3.3
.param vdd_val=3.3
.param temp_c=125.0

* ---- gf180mcu models ------------------------------------------------
.include "/Users/rwalters/.volare/gf180mcuD/libs.tech/ngspice/design.ngspice"
.lib "/Users/rwalters/.volare/gf180mcuD/libs.tech/ngspice/sm141064.ngspice" ss
.lib "/Users/rwalters/.volare/gf180mcuD/libs.tech/ngspice/sm141064.ngspice" bjt_ss
.lib "/Users/rwalters/.volare/gf180mcuD/libs.tech/ngspice/sm141064.ngspice" diode_ss
.lib "/Users/rwalters/.volare/gf180mcuD/libs.tech/ngspice/sm141064.ngspice" res_ss
.lib "/Users/rwalters/.volare/gf180mcuD/libs.tech/ngspice/sm141064.ngspice" moscap_ss
.lib "/Users/rwalters/.volare/gf180mcuD/libs.tech/ngspice/sm141064.ngspice" mimcap_ss

.temp 125.0

* ---- testbench ------------------------------------------------------
.include "/Users/rwalters/GitHub/gf180-trng/.loom/worktrees/issue-4/sim/tb/inv-stage-noise/tb_inv_stage.sp"

* ---- measurement ----------------------------------------------------
.control
set numdgt=10
set noaskquit
  op
  ac dec 10 1e3 1e11
  noise v(out) vn dec 10 1e3 1e11 1
  noise v(out) vn dec 10 1e8 1e11 1
  setplot noise2
  let m_vtrip = op1.v(out)
  let m_gain_1meg = mag(ac1.v(out)[30])
  let m_gain_100meg = mag(ac1.v(out)[50])
  let m_gain_1g = mag(ac1.v(out)[60])
  let m_inoise_dens_1meg = noise1.inoise_spectrum[30]
  let m_inoise_dens_10meg = noise1.inoise_spectrum[40]
  let m_inoise_dens_100meg = noise1.inoise_spectrum[50]
  let m_inoise_dens_1g = noise1.inoise_spectrum[60]
  let m_inoise_dens_10g = noise1.inoise_spectrum[70]
  let m_onoise_dens_1meg = noise1.onoise_spectrum[30]
  let m_onoise_dens_1g = noise1.onoise_spectrum[60]
  let m_onoise_rms_1k_100g = noise2.onoise_total
  let m_onoise_rms_100meg_100g = noise4.onoise_total
  print m_vtrip
  print m_gain_1meg
  print m_gain_100meg
  print m_gain_1g
  print m_inoise_dens_1meg
  print m_inoise_dens_10meg
  print m_inoise_dens_100meg
  print m_inoise_dens_1g
  print m_inoise_dens_10g
  print m_onoise_dens_1meg
  print m_onoise_dens_1g
  print m_onoise_rms_1k_100g
  print m_onoise_rms_100meg_100g
.endc
.end
