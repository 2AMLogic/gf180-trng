* ro-inv-05stage-jitter @ ss_27c_3.30v -- GENERATED by sim/harness, do not edit
* corner=ss (all device families slow)
* temp=27.0 C  vdd=3.3 V  pdk=gf180mcuD@c6d73a35f524070e85faff4a6a9eef49553ebc2b

* ---- PVT parameters -------------------------------------------------
.param vdd_nom=3.3
.param vdd_val=3.3
.param temp_c=27.0
.param vn_rms=2.2361e-3
.param vn_dt=1e-11

* ---- gf180mcu models ------------------------------------------------
.include "/Users/rwalters/.volare/gf180mcuD/libs.tech/ngspice/design.ngspice"
.option seed=1
.lib "/Users/rwalters/.volare/gf180mcuD/libs.tech/ngspice/sm141064.ngspice" ss
.lib "/Users/rwalters/.volare/gf180mcuD/libs.tech/ngspice/sm141064.ngspice" bjt_ss
.lib "/Users/rwalters/.volare/gf180mcuD/libs.tech/ngspice/sm141064.ngspice" diode_ss
.lib "/Users/rwalters/.volare/gf180mcuD/libs.tech/ngspice/sm141064.ngspice" res_ss
.lib "/Users/rwalters/.volare/gf180mcuD/libs.tech/ngspice/sm141064.ngspice" moscap_ss
.lib "/Users/rwalters/.volare/gf180mcuD/libs.tech/ngspice/sm141064.ngspice" mimcap_ss

.temp 27.0

* ---- testbench ------------------------------------------------------
.include "/Users/rwalters/GitHub/gf180-trng/.loom/worktrees/issue-4/sim/tb/ro-inv-05stage-jitter/tb_ro_inv_05stage_jitter.sp"

* ---- measurement ----------------------------------------------------
.control
set numdgt=10
set noaskquit
  tran 1p 170n
  meas tran ts40 when v(xs40)=0 rise=5
  meas tran ts60 when v(xs60)=0 rise=5
  let tc = vector(129)
  let k = 2
  while k <= 130
    meas tran tk when v(xing)=0 rise=$&k
    let tc[k-2] = tk
    let k = k + 1
  end
  let tbar = (tc[128] - tc[0])/128
  let r1 = (tc[1,128] - tc[0,127]) - 1*tbar
  let r2 = (tc[2,128] - tc[0,126]) - 2*tbar
  let r4 = (tc[4,128] - tc[0,124]) - 4*tbar
  let r8 = (tc[8,128] - tc[0,120]) - 8*tbar
  let r16 = (tc[16,128] - tc[0,112]) - 16*tbar
  let r32 = (tc[32,128] - tc[0,96]) - 32*tbar
  let m_period = tbar
  let m_f_osc = 1/tbar
  let m_slew_v_per_s = 0.2*mean(v(vdd))/(ts60-ts40)
  let m_sigma_1 = sqrt(mean(r1*r1)/(1 - 1/128))
  let m_sigma_2 = sqrt(mean(r2*r2)/(1 - 2/128))
  let m_sigma_4 = sqrt(mean(r4*r4)/(1 - 4/128))
  let m_sigma_8 = sqrt(mean(r8*r8)/(1 - 8/128))
  let m_sigma_16 = sqrt(mean(r16*r16)/(1 - 16/128))
  let m_sigma_32 = sqrt(mean(r32*r32)/(1 - 32/128))
  print m_period
  print m_f_osc
  print m_slew_v_per_s
  print m_sigma_1
  print m_sigma_2
  print m_sigma_4
  print m_sigma_8
  print m_sigma_16
  print m_sigma_32
.endc
.end
