* noise-floor-resistor @ tt_27c_3.30v -- GENERATED by sim/harness, do not edit
* corner=tt (all device families typical)
* temp=27.0 C  vdd=3.3 V  pdk=gf180mcuD@c6d73a35f524070e85faff4a6a9eef49553ebc2b

* ---- PVT parameters -------------------------------------------------
.param vdd_nom=3.3
.param vdd_val=3.3
.param temp_c=27.0

* ---- gf180mcu models ------------------------------------------------
.include "/Users/rwalters/.volare/gf180mcuD/libs.tech/ngspice/design.ngspice"
.lib "/Users/rwalters/.volare/gf180mcuD/libs.tech/ngspice/sm141064.ngspice" typical
.lib "/Users/rwalters/.volare/gf180mcuD/libs.tech/ngspice/sm141064.ngspice" bjt_typical
.lib "/Users/rwalters/.volare/gf180mcuD/libs.tech/ngspice/sm141064.ngspice" diode_typical
.lib "/Users/rwalters/.volare/gf180mcuD/libs.tech/ngspice/sm141064.ngspice" res_typical
.lib "/Users/rwalters/.volare/gf180mcuD/libs.tech/ngspice/sm141064.ngspice" moscap_typical
.lib "/Users/rwalters/.volare/gf180mcuD/libs.tech/ngspice/sm141064.ngspice" mimcap_typical

.temp 27.0

* ---- testbench ------------------------------------------------------
.include "/Users/rwalters/GitHub/gf180-trng/.loom/worktrees/issue-4/sim/tb/noise-floor-resistor/tb_rdiv.sp"

* ---- measurement ----------------------------------------------------
.control
set numdgt=10
set noaskquit
  noise v(nout) vn dec 10 1e3 1e6 1
  setplot noise2
  let m_onoise_dens_1k = noise1.onoise_spectrum[0]
  let m_onoise_dens_1meg = noise1.onoise_spectrum[30]
  let m_inoise_dens_1k = noise1.inoise_spectrum[0]
  let m_onoise_total_1k_1meg = onoise_total
  let m_inoise_total_1k_1meg = inoise_total
  print m_onoise_dens_1k
  print m_onoise_dens_1meg
  print m_inoise_dens_1k
  print m_onoise_total_1k_1meg
  print m_inoise_total_1k_1meg
.endc
.end
