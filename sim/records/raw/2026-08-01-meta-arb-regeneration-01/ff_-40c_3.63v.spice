* meta-arb-regeneration @ ff_-40c_3.63v -- GENERATED by sim/harness, do not edit
* corner=ff (all device families fast)
* temp=-40.0 C  vdd=3.63 V  pdk=gf180mcuD@c6d73a35f524070e85faff4a6a9eef49553ebc2b

* ---- PVT parameters -------------------------------------------------
.param vdd_nom=3.3
.param vdd_val=3.63
.param temp_c=-40.0

* ---- gf180mcu models ------------------------------------------------
.include "/Users/rwalters/.volare/gf180mcuD/libs.tech/ngspice/design.ngspice"
.lib "/Users/rwalters/.volare/gf180mcuD/libs.tech/ngspice/sm141064.ngspice" ff
.lib "/Users/rwalters/.volare/gf180mcuD/libs.tech/ngspice/sm141064.ngspice" bjt_ff
.lib "/Users/rwalters/.volare/gf180mcuD/libs.tech/ngspice/sm141064.ngspice" diode_ff
.lib "/Users/rwalters/.volare/gf180mcuD/libs.tech/ngspice/sm141064.ngspice" res_ff
.lib "/Users/rwalters/.volare/gf180mcuD/libs.tech/ngspice/sm141064.ngspice" moscap_ff
.lib "/Users/rwalters/.volare/gf180mcuD/libs.tech/ngspice/sm141064.ngspice" mimcap_ff

.temp -40.0
.options reltol=1e-5

* ---- device under test (schematic-derived, design/netlist.py) -------
.include "/Users/rwalters/GitHub/gf180-trng/.loom/worktrees/issue-43/design/meta_arb.spice"

* ---- testbench ------------------------------------------------------
.include "/Users/rwalters/GitHub/gf180-trng/.loom/worktrees/issue-43/sim/tb/meta-arb-regeneration/tb_meta_arb_regeneration.sp"

* ---- measurement ----------------------------------------------------
.control
set numdgt=10
set noaskquit
  tran 0.5p 9n
  meas tran ts when v(sn)=v(vth) rise=1
  meas tran tq1 when v(q1)=v(vth) fall=1
  meas tran tq2 when v(q2)=v(vth) fall=1
  meas tran tq3 when v(q3)=v(vth) fall=1
  meas tran tq4 when v(q4)=v(vth) fall=1
  meas tran tq5 when v(q5)=v(vth) fall=1
  meas tran tq6 when v(q6)=v(vth) fall=1
  meas tran vq0 find v(q0) at=8.5n
  meas tran vqn0 find v(qn0) at=8.5n
  let ln10 = 2.302585092994046
  let m_t_res_100p_s = tq6-ts
  let m_t_res_10p_s = tq5-ts
  let m_t_res_1p_s = tq4-ts
  let m_t_res_100f_s = tq3-ts
  let m_t_res_10f_s = tq2-ts
  let m_t_res_1f_s = tq1-ts
  let m_tau_100p_10p_s = (tq5-tq6)/ln10
  let m_tau_10p_1p_s = (tq4-tq5)/ln10
  let m_tau_1p_100f_s = (tq3-tq4)/ln10
  let m_tau_100f_10f_s = (tq2-tq3)/ln10
  let m_tau_10f_1f_s = (tq1-tq2)/ln10
  let m_v_q0_bal_v = vq0
  let m_v_qn0_bal_v = vqn0
  let m_v_diff_bal_v = abs(vq0-vqn0)
  print m_t_res_100p_s
  print m_t_res_10p_s
  print m_t_res_1p_s
  print m_t_res_100f_s
  print m_t_res_10f_s
  print m_t_res_1f_s
  print m_tau_100p_10p_s
  print m_tau_10p_1p_s
  print m_tau_1p_100f_s
  print m_tau_100f_10f_s
  print m_tau_10f_1f_s
  print m_v_q0_bal_v
  print m_v_qn0_bal_v
  print m_v_diff_bal_v
.endc
.end
