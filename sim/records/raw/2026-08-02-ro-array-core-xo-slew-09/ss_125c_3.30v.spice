* ro-array-core-xo-slew @ ss_125c_3.30v -- GENERATED by sim/harness, do not edit
* corner=ss (all device families slow)
* temp=125.0 C  vdd=3.3 V  pdk=gf180mcuD@c6d73a35f524070e85faff4a6a9eef49553ebc2b

* ---- PVT parameters -------------------------------------------------
.param vdd_nom=3.3
.param vdd_val=3.3
.param temp_c=125.0

* ---- gf180mcu models ------------------------------------------------
.include "/Users/rwalters/.volare/gf180mcuD/libs.tech/ngspice/design.ngspice"
.lib "/Users/rwalters/.volare/gf180mcuD/libs.tech/ngspice/sm141064.ngspice" ss
.lib "/Users/rwalters/.volare/gf180mcuD/libs.tech/ngspice/sm141064.ngspice" bjt_ss
.lib "/Users/rwalters/.volare/gf180mcuD/libs.tech/ngspice/sm141064.ngspice" diode_ss
.lib "/Users/rwalters/.volare/gf180mcuD/libs.tech/ngspice/sm141064.ngspice" res_ss
.lib "/Users/rwalters/.volare/gf180mcuD/libs.tech/ngspice/sm141064.ngspice" moscap_ss
.lib "/Users/rwalters/.volare/gf180mcuD/libs.tech/ngspice/sm141064.ngspice" mimcap_ss

.temp 125.0

* ---- device under test (schematic-derived, design/netlist.py) -------
.include "/Users/rwalters/GitHub/gf180-trng/.loom/worktrees/issue-13/design/ro_array_core.spice"

* ---- testbench ------------------------------------------------------
.include "/Users/rwalters/GitHub/gf180-trng/.loom/worktrees/issue-13/sim/tb/ro-array-core-xo-slew/tb_ro_array_core_xo_slew.sp"

* ---- measurement ----------------------------------------------------
.control
set numdgt=10
set noaskquit
  tran 2p 140n 40n
  let dxo = deriv(v(xo))
  let dro = deriv(v(xdut.ro1))
  meas tran sxr max dxo from=50n to=135n
  meas tran sxf min dxo from=50n to=135n
  meas tran srr max dro from=50n to=135n
  meas tran srf min dro from=50n to=135n
  meas tran ta when v(xdut.ro1)=v(v40) rise=2
  meas tran tb when v(xdut.ro1)=v(v60) rise=2
  meas tran tc when v(xdut.ro1)=v(v40) rise=4
  meas tran td when v(xdut.ro1)=v(v60) rise=4
  meas tran xhi max v(xo) from=50n to=135n
  meas tran xlo min v(xo) from=50n to=135n
  let m_xo_slew_rise_v_per_s = sxr
  let m_xo_slew_fall_v_per_s = sxf
  let m_ro1_slew_rise_v_per_s = srr
  let m_ro1_slew_fall_v_per_s = srf
  let m_ro1_band_slew_a_v_per_s = 0.2*mean(v(vsup))/(tb-ta)
  let m_ro1_band_slew_b_v_per_s = 0.2*mean(v(vsup))/(td-tc)
  let m_xo_swing_v = xhi-xlo
  print m_xo_slew_rise_v_per_s
  print m_xo_slew_fall_v_per_s
  print m_ro1_slew_rise_v_per_s
  print m_ro1_slew_fall_v_per_s
  print m_ro1_band_slew_a_v_per_s
  print m_ro1_band_slew_b_v_per_s
  print m_xo_swing_v
.endc
.end
