* sampler-dff-active-current @ sf_27c_3.63v -- GENERATED by sim/harness, do not edit
* corner=sf (slow NMOS / fast PMOS, passives typical)
* temp=27.0 C  vdd=3.63 V  pdk=gf180mcuD@c6d73a35f524070e85faff4a6a9eef49553ebc2b

* ---- PVT parameters -------------------------------------------------
.param vdd_nom=3.3
.param vdd_val=3.63
.param temp_c=27.0

* ---- gf180mcu models ------------------------------------------------
.include "/Users/rwalters/.volare/gf180mcuD/libs.tech/ngspice/design.ngspice"
.lib "/Users/rwalters/.volare/gf180mcuD/libs.tech/ngspice/sm141064.ngspice" sf
.lib "/Users/rwalters/.volare/gf180mcuD/libs.tech/ngspice/sm141064.ngspice" bjt_typical
.lib "/Users/rwalters/.volare/gf180mcuD/libs.tech/ngspice/sm141064.ngspice" diode_typical
.lib "/Users/rwalters/.volare/gf180mcuD/libs.tech/ngspice/sm141064.ngspice" res_typical
.lib "/Users/rwalters/.volare/gf180mcuD/libs.tech/ngspice/sm141064.ngspice" moscap_typical
.lib "/Users/rwalters/.volare/gf180mcuD/libs.tech/ngspice/sm141064.ngspice" mimcap_typical

.temp 27.0

* ---- device under test (schematic-derived, design/netlist.py) -------
.include "/Users/rwalters/GitHub/gf180-trng/.loom/worktrees/issue-14/design/sampler_core.spice"

* ---- testbench ------------------------------------------------------
.include "/Users/rwalters/GitHub/gf180-trng/.loom/worktrees/issue-14/sim/tb/sampler-dff-active-current/tb_sampler_dff_active_current.sp"

* ---- measurement ----------------------------------------------------
.control
set numdgt=10
set noaskquit
  tran 20p 60n
  meas tran q1a find v(q1) at=22n
  meas tran q1b find v(q1) at=28n
  meas tran q1c find v(q1) at=32n
  meas tran q1d find v(q1) at=38n
  meas tran q1e find v(q1) at=32n
  meas tran q1f find v(q1) at=53n
  meas tran q2a find v(q2) at=22n
  meas tran q2b find v(q2) at=28n
  meas tran q2c find v(q2) at=32n
  meas tran q2d find v(q2) at=38n
  meas tran q2e find v(q2) at=32n
  meas tran q2f find v(q2) at=53n
  meas tran qv_pre find v(qv) at=19n
  meas tran qv_post find v(qv) at=40n
  meas tran qb_pre find v(qb) at=40n
  meas tran qb_post find v(qb) at=50n
  meas tran vdd_mean avg v(vsup) from=32n to=53n
  let cq = 1e-9
  let ndw = 6
  let nopen = 11
  let nshut = 10
  let m_q_d_shut_c = -cq*(q2b-q2a)/ndw
  let m_q_d_open_c = -cq*(q2d-q2c)/ndw
  let m_e_d_shut_j = -cq*(q2b-q2a)/ndw*vdd_mean
  let m_e_d_open_j = -cq*(q2d-q2c)/ndw*vdd_mean
  let m_q_clkcyc_xsv_c = -cq*(q1f-q1e)
  let m_e_clkcyc_xsv_j = -cq*(q1f-q1e)*vdd_mean
  let m_q_clkcyc_xsb_resid_c = -cq*(q2f-q2e) - nshut*(-cq*(q2b-q2a)/ndw) - nopen*(-cq*(q2d-q2c)/ndw)
  let m_q_cyc_xsb_total_c = -cq*(q2f-q2e)
  let m_q_d_shut_xsv_c = -cq*(q1b-q1a)/ndw
  let m_q_d_open_xsv_c = -cq*(q1d-q1c)/ndw
  let m_vdd_mean_v = vdd_mean
  let m_qv_pre_v = qv_pre
  let m_qv_post_v = qv_post
  let m_qb_pre_v = qb_pre
  let m_qb_post_v = qb_post
  print m_q_d_shut_c
  print m_q_d_open_c
  print m_e_d_shut_j
  print m_e_d_open_j
  print m_q_clkcyc_xsv_c
  print m_e_clkcyc_xsv_j
  print m_q_clkcyc_xsb_resid_c
  print m_q_cyc_xsb_total_c
  print m_q_d_shut_xsv_c
  print m_q_d_open_xsv_c
  print m_vdd_mean_v
  print m_qv_pre_v
  print m_qv_post_v
  print m_qb_pre_v
  print m_qb_post_v
.endc
.end
