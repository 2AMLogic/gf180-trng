* device-leakage-03v3 @ fs_-40c_3.63v -- GENERATED by sim/harness, do not edit
* corner=fs (fast NMOS / slow PMOS, passives typical)
* temp=-40.0 C  vdd=3.63 V  pdk=gf180mcuD@c6d73a35f524070e85faff4a6a9eef49553ebc2b

* ---- PVT parameters -------------------------------------------------
.param vdd_nom=3.3
.param vdd_val=3.63
.param temp_c=-40.0

* ---- gf180mcu models ------------------------------------------------
.include "/Users/rwalters/.volare/gf180mcuD/libs.tech/ngspice/design.ngspice"
.lib "/Users/rwalters/.volare/gf180mcuD/libs.tech/ngspice/sm141064.ngspice" fs
.lib "/Users/rwalters/.volare/gf180mcuD/libs.tech/ngspice/sm141064.ngspice" bjt_typical
.lib "/Users/rwalters/.volare/gf180mcuD/libs.tech/ngspice/sm141064.ngspice" diode_typical
.lib "/Users/rwalters/.volare/gf180mcuD/libs.tech/ngspice/sm141064.ngspice" res_typical
.lib "/Users/rwalters/.volare/gf180mcuD/libs.tech/ngspice/sm141064.ngspice" moscap_typical
.lib "/Users/rwalters/.volare/gf180mcuD/libs.tech/ngspice/sm141064.ngspice" mimcap_typical

.temp -40.0

* ---- testbench ------------------------------------------------------
.include "/Users/rwalters/GitHub/gf180-trng/.loom/worktrees/issue-32/sim/tb/device-leakage-03v3/tb_device_leakage.sp"

* ---- measurement ----------------------------------------------------
.control
set numdgt=10
set noaskquit
  op
  let m_ioff_nfet_a = i(vdn)
  let m_ioff_pfet_a = i(vdp)
  let m_ioff_nfet_a_per_um = i(vdn)/10
  let m_ioff_pfet_a_per_um = i(vdp)/10
  print m_ioff_nfet_a
  print m_ioff_pfet_a
  print m_ioff_nfet_a_per_um
  print m_ioff_pfet_a_per_um
.endc
.end
