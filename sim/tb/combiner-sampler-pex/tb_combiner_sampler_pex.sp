* combiner-sampler-pex -- the assembled combiner/sampler block (combiner_sampler)
* under a deterministic two-input, clock and reset schedule, for `klt pex` (#418).
* GENERATED by sim/tb/combiner-sampler-pex/stimulus.py -- do not edit by hand.
*
* A circuit body for `klt sim`: no .control/.end. klt sim appends the corner's
* .lib/.temp cards, the .meas cards from request.json, `alter vsupply=<V>` for
* the supply corner, and the analysis. The one .include below is the schematic
* DUT; `klt pex` re-points exactly that line at the netlist it extracts from
* layout/blocks/combiner_sampler/combiner_sampler.gds and reuses everything
* else byte for byte on both sides.
*
* rn1/rn2 stand in for the two ring outputs: deterministic logic steps, not
* oscillators. Every driven input is a 0/1 schedule (l* sources) scaled by
* the corner's own vdd, so a step is full-swing at every supply corner. The
* *n monitors are supply-normalised copies of DUT nodes; they draw no current.

.include "combiner_sampler_schematic.spice"

* switches design.ngspice sets (its values, verbatim)
.param sw_stat_global=0 sw_stat_mismatch=0 mc_skew=3 res_mc_skew=3 cap_mc_skew=3 fnoicor=0

vsupply vdd 0 dc 3.3
vvss vss 0 dc 0
vvsubs vsubs 0 dc 0

vlrn1 lrn1 0 pwl(0n 0 80n 0 80.1n 1 120n 1 120.1n 0 160n 0 160.1n 1 200n 1 200.1n 0 240n 0 240.1n 1 320n 1 320.1n 0)
vlrn2 lrn2 0 pwl(0n 1 40n 1 40.1n 0 80n 0 80.1n 1 120n 1 120.1n 0 200n 0 200.1n 1 280n 1 280.1n 0 320n 0 320.1n 1)
vlclk lclk 0 pwl(0n 0 20n 0 20.1n 1 40n 1 40.1n 0 60n 0 60.1n 1 80n 1 80.1n 0 100n 0 100.1n 1 120n 1 120.1n 0 140n 0 140.1n 1 160n 1 160.1n 0 180n 0 180.1n 1 200n 1 200.1n 0 220n 0 220.1n 1 240n 1 240.1n 0 260n 0 260.1n 1 280n 1 280.1n 0 300n 0 300.1n 1 320n 1 320.1n 0 340n 0 340.1n 1 360n 1 360.1n 0)
vlrst lrst 0 pwl(0n 0 70n 0 70.1n 1 325n 1 325.1n 0)
brn1 rn1 0 v='v(vdd)*v(lrn1)'
brn2 rn2 0 v='v(vdd)*v(lrn2)'
bclk clk 0 v='v(vdd)*v(lclk)'
brst rst_n 0 v='v(vdd)*v(lrst)'

xdut rn1 rn2 ro1 ro2 clk vdd xo raw_bit raw_valid ring_bit1 ring_bit2 rst_n vss vsubs combiner_sampler

bclkn clkn 0 v='v(clk)/v(vdd)'
brst_nn rst_nn 0 v='v(rst_n)/v(vdd)'
braw_bitn raw_bitn 0 v='v(raw_bit)/v(vdd)'
braw_validn raw_validn 0 v='v(raw_valid)/v(vdd)'
bring_bit1n ring_bit1n 0 v='v(ring_bit1)/v(vdd)'
bring_bit2n ring_bit2n 0 v='v(ring_bit2)/v(vdd)'
bxon xon 0 v='v(xo)/v(vdd)'
bro1n ro1n 0 v='v(ro1)/v(vdd)'
bro2n ro2n 0 v='v(ro2)/v(vdd)'
