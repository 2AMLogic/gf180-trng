* smoke-op -- trivial resistor divider (harness bring-up, NOT a design block)
vdd vdd 0 dc vdd_val
r1 vdd out 10k
r2 out 0 10k
