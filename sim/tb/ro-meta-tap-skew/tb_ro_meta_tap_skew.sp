* ro-meta-tap-skew -- the tap's strobe-path skew, trim sensitivity and power.
*
* DUT: design/ro_meta_tap.spice, exported from design/xschem/ro_meta_tap.sch
* by design/netlist.py. Nothing about the DUT is redefined here; this
* fragment supplies rails, an xo-like stimulus, and measurement-only
* elements.
*
* WHAT THIS MEASURES
*
* The architecture survey's second objection to the metastability hybrid
* (section B.4) is not about simulation at all: a metastable arbiter's
* balance point drifts with PVT and mismatch, and drifting off balance
* degrades entropy SILENTLY -- the tap keeps producing bits, they just
* stop being random. The survey's answer in the literature is a
* calibration loop. Before designing one, two numbers are needed:
*
*   1. How much trim does a given imbalance buy? -- dt per fF of load
*      difference between the two strobe paths.
*   2. How far does a FIXED trim setting move over PVT? -- the same
*      imbalance measured at every corner. Compare that spread against tau
*      from sim/tb/meta-arb-regeneration/ and the answer to "can a one-time
*      trim hold the balance point?" stops being a matter of opinion.
*
* Four tap instances carry a deliberate imbalance ctb - cta of 0.05, 0.5,
* 1 and 2 fF. Their spread also checks linearity, which is the testbench's
* own self-check: if dt(2 fF) is not close to twice dt(1 fF) the skew is
* not coming from where this testbench thinks it is.
*
* WHY NO EXACTLY-BALANCED INSTANCE
*
* Deliberately absent. Two structurally identical paths in a noiseless
* nominal-model simulation give dt = 0 to solver roundoff, which is not a
* measurement of the balance point -- it is a restatement of the schematic.
* The real balance point is set by mismatch, which these models do not
* carry. Reporting "dt = 0, therefore balanced" would be exactly the kind
* of overclaim DR-0011 exists to prevent.
*
* POWER
*
* xtp is a fifth instance on its own supply branch (vddp), driven by a
* PERIODIC stimulus at 480 MHz -- close to the 9.6e8 transitions/s the
* shipped array's xo node was measured at (2026-08-01-ro-array-core-power-04).
* Energy per xin period is the rate-independent figure; p_tap_w is that
* energy at this stimulus rate, and the record states the rate. The charge
* integrator fqp/cqp/rqp is the same construction sim/tb/ro-inv-05stage-power/
* and sim/tb/ro-array-core-power/ use, with the same sign convention: v(qp)
* accumulates charge delivered INTO the branch, so i_tap_a/p_tap_w come out
* negative and the magnitudes are the physical ones.
*
* METHOD NOTES
*
*   - Stimulus edges are 150 ps, chosen to resemble what a minimum-width
*     xor2 delivers into one gate load rather than an idealised step. The
*     skew being measured is generated by the trim loads inside the tap; a
*     faster or slower input edge changes it only to second order, but the
*     record states the edge rate because "second order" is not "zero".
*   - The four skew instances see a SINGLE-SHOT stimulus: xin rises at 2 ns
*     (assert: pa and pb driven low together) and falls at 6.15 ns
*     (release: the race). One event per instance makes every .meas edge
*     index unambiguous, which a periodic stimulus would not.
*   - .ic pins each arbiter's mq low at t = 0, for the reason given in
*     sim/tb/meta-arb-regeneration/: with both inputs high the latch has a
*     metastable DC solution the operating point could otherwise land on.
*   - bvth is a measurement-only mid-supply reference.

vsup vsup 0 dc vdd_val
bvth vth 0 v = 0.5*vdd_val

* single-shot: assert at 2 ns, release at 6.15 ns
vin xin 0 pulse(0 {vdd_val} 2n 150p 150p 4n 100n)

* periodic, 480 MHz (2.084 ns period) -- the array's measured xo rate
vinp xinp 0 pulse(0 {vdd_val} 0 150p 150p 0.892n 2.084n)

xt1 xin mo1 vsup 0 ro_meta_tap cta=2f ctb=2.05f cld=0.5f
xt2 xin mo2 vsup 0 ro_meta_tap cta=2f ctb=2.5f cld=0.5f
xt3 xin mo3 vsup 0 ro_meta_tap cta=2f ctb=3f cld=0.5f
xt4 xin mo4 vsup 0 ro_meta_tap cta=2f ctb=4f cld=0.5f

* metered instance on its own supply branch
vp vsup vddp dc 0
xtp xinp mop vddp 0 ro_meta_tap cta=2f ctb=2.5f cld=0.5f
fqp qp 0 vp 1
cqp qp 0 1n
rqp qp 0 1e12

.ic v(xt1.mq)=0
.ic v(xt2.mq)=0
.ic v(xt3.mq)=0
.ic v(xt4.mq)=0
.ic v(xtp.mq)=0
.ic v(qp)=0
