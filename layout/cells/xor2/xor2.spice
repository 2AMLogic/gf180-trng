* xor2 -- LVS reference (schematic-side) netlist.
*
* Hand-written, NOT a copy of `klt extract` output -- see
* layout/testcells/trng_tc_inv.spice for why that distinction matters (an
* LVS run whose reference is the extractor's own output proves nothing).
* This is transcribed directly from design/ro_array_core.spice's
* `.subckt xor2` (from design/xschem/xor2.sch), independent of the layout
* in this directory, and `klt lvs` is asked to agree the drawn geometry
* implements it.
*
* Device topology (design/ro_array_core.spice's `.subckt xor2`, at that
* file's own sizing -- every L=0.28u):
*
*   Input inverters:
*     MPIA/MNIA: an = NOT(a)   (W=0.44/0.22)
*     MPIB/MNIB: bn = NOT(b)   (W=0.44/0.22)
*   XOR core:
*     MP1/MP2:   mid pulled to vdd through a or b        (W=0.88, parallel)
*     MP3/MP4:   y pulled to mid through an or bn         (W=0.88, parallel)
*     MN1/MN2:   y pulled to vss through a THEN b         (W=0.44, series)
*     MN3/MN4:   y pulled to vss through an THEN bn       (W=0.44, series)
*
* Device sizes must agree with layout/cells/xor2/build.py's NMOS/PMOS
* device lists -- `klt lvs` compares W and L as device properties, not
* just topology.
*
* Bulk terminals: every cell, ring and block draws an Nwell tap tied to
* `vdd` and a substrate tap tied to `vss` (layout/testcells/gdsii.py's
* `add_taps`; klt >= 0.8.0's `comp.tap_distance.*` requires them), so the
* extractor reports every PMOS bulk as `vdd` and every NMOS bulk as
* `vss` -- the same bulk connections design/xschem/ wires. There is no
* `vsubs` pin and no floating-well net any more.

.SUBCKT xor2 a b y vdd vss
MNIA an a vss vss nfet L=0.28U W=0.22U
MNIB bn b vss vss nfet L=0.28U W=0.22U
MN1 y a s1 vss nfet L=0.28U W=0.44U
MN2 s1 b vss vss nfet L=0.28U W=0.44U
MN3 y an s2 vss nfet L=0.28U W=0.44U
MN4 s2 bn vss vss nfet L=0.28U W=0.44U
MPIA an a vdd vdd pfet L=0.28U W=0.44U
MPIB bn b vdd vdd pfet L=0.28U W=0.44U
MP1 mid a vdd vdd pfet L=0.28U W=0.88U
MP2 mid b vdd vdd pfet L=0.28U W=0.88U
MP3 y an mid vdd pfet L=0.28U W=0.88U
MP4 y bn mid vdd pfet L=0.28U W=0.88U
.ENDS xor2
