* sampler_dff -- LVS reference (schematic-side) netlist.
*
* Hand-written, NOT a copy of `klt extract` output -- see
* layout/testcells/trng_tc_inv.spice for why that distinction matters (an
* LVS run whose reference is the extractor's own output proves nothing).
* This is transcribed directly from design/sampler_core.spice's
* `.subckt sampler_dff` (from design/xschem/sampler_dff.sch), independent
* of the layout in this directory, and `klt lvs` is asked to agree the
* drawn geometry implements it.
*
* Device topology (design/sampler_core.spice's `.subckt sampler_dff`, at
* that file's own sizing -- every L=0.28u; W=0.22u for the seven
* clock/data-path NMOS legs listed first below, W=0.44u everywhere else):
*
*   MPC/MNC:     clkb = NOT(clk)
*   MTDP/MTDN:   master transmission gate: d -> m, gated by clk/clkb
*   MIMPA/MIMPB/MIMNA/MIMNB: master cross-coupled latch (mb = NOT(m));
*                MIMPB/MIMNB gated by rst_n -- the async set pulling mb
*                high (DR-0014)
*   MIM2P/MIM2N: mc = NOT(mb)
*   MFMP/MFMN:   master feedback transmission gate: mc -> m, gated by
*                clkb/clk (closes the latch opposite-phase from MTDP/MTDN)
*   MTSP/MTSN:   slave transmission gate: mb -> s, gated by clkb/clk
*   MISP/MISN:   q = NOT(s)
*   MIS2PA/MIS2PB/MIS2NA/MIS2NB: slave cross-coupled latch (qb = NOT(q));
*                MIS2PB/MIS2NB gated by rst_n -- the async reset's second
*                stage, holding q low
*   MFSP/MFSN:   slave feedback transmission gate: qb -> s, gated by
*                clk/clkb
*
* Device sizes must agree with layout/cells/sampler_dff/build.py's
* NMOS/PMOS device lists -- `klt lvs` compares W and L as device
* properties, not just topology.
*
* Bulk terminals: every cell, ring and block draws an Nwell tap tied to
* `vdd` and a substrate tap tied to `vss` (layout/testcells/gdsii.py's
* `add_taps`; klt >= 0.8.0's `comp.tap_distance.*` requires them), so the
* extractor reports every PMOS bulk as `vdd` and every NMOS bulk as
* `vss` -- the same bulk connections design/xschem/ wires. There is no
* `vsubs` pin and no floating-well net any more.

.SUBCKT sampler_dff d clk rst_n q vdd vss
MNC clkb clk vss vss nfet L=0.28U W=0.22U
MTDN d clkb m vss nfet L=0.28U W=0.22U
MIM2N mc mb vss vss nfet L=0.28U W=0.22U
MFMN mc clk m vss nfet L=0.28U W=0.22U
MTSN mb clk s vss nfet L=0.28U W=0.22U
MISN q s vss vss nfet L=0.28U W=0.22U
MFSN qb clkb s vss nfet L=0.28U W=0.22U
MIMNA mb m mmid vss nfet L=0.28U W=0.44U
MIMNB mmid rst_n vss vss nfet L=0.28U W=0.44U
MIS2NA qb q s2mid vss nfet L=0.28U W=0.44U
MIS2NB s2mid rst_n vss vss nfet L=0.28U W=0.44U
MPC clkb clk vdd vdd pfet L=0.28U W=0.44U
MTDP d clk m vdd pfet L=0.28U W=0.44U
MIMPA mb m vdd vdd pfet L=0.28U W=0.44U
MIMPB mb rst_n vdd vdd pfet L=0.28U W=0.44U
MIM2P mc mb vdd vdd pfet L=0.28U W=0.44U
MFMP mc clkb m vdd pfet L=0.28U W=0.44U
MTSP mb clkb s vdd pfet L=0.28U W=0.44U
MISP q s vdd vdd pfet L=0.28U W=0.44U
MIS2PA qb q vdd vdd pfet L=0.28U W=0.44U
MIS2PB qb rst_n vdd vdd pfet L=0.28U W=0.44U
MFSP qb clk s vdd pfet L=0.28U W=0.44U
.ENDS sampler_dff
