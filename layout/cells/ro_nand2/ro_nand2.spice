* ro_nand2 -- LVS reference (schematic-side) netlist.
*
* Hand-written, NOT a copy of `klt extract` output -- see
* layout/testcells/trng_tc_inv.spice for why that distinction matters (an
* LVS run whose reference is the extractor's own output proves nothing).
* This is transcribed directly from design/xschem/ro_nand2.sch's six
* devices (design/ro_array_core.spice's `.subckt ro_nand2`), at the
* schematic's own default parameters `wstv=0.22u lstv=2u` -- ring1's value,
* the same convention layout/cells/ro_stage/ uses for its own first drawn
* variant. Independent of the layout in this directory; `klt lvs` is asked
* to agree the drawn geometry implements it.
*
* Device topology:
*
*   XMph py vss vddr vddr  pfet L=lstv W=wstv   -- starve, gate=vss
*   XMpa y  a  py  vddr    pfet L=0.28 W=0.44   -- pull-up, gate=a
*   XMpb y  en py  vddr    pfet L=0.28 W=0.44   -- pull-up, gate=en (parallel with XMpa)
*   XMna y  a  nm  vss     nfet L=0.28 W=0.44   -- pull-down, gate=a
*   XMnb nm en ny  vss     nfet L=0.28 W=0.44   -- pull-down, gate=en (series with XMna)
*   XMnt ny vddr vss vss   nfet L=lstv W=wstv   -- starve, gate=vddr
*
* XMpa/XMpb share both terminals (source=py, drain=y) -- a parallel pull-up
* pair, either input low pulling y high through the shared starve device
* XMph. XMna/XMnb are in series (y-nm-ny) -- both a and en must be high to
* pull y low through the shared starve device XMnt. Together: a plain NAND2
* (y = NOT(a AND en)), with en low forcing y high regardless of a -- the
* mechanism the ring uses to stop oscillating. See
* layout/cells/ro_nand2/build.py's module docstring for the full account,
* including how the drawn geometry realises the parallel XMpa/XMpb pair
* (two diffusion islands tied by an explicit metal1 riser, not a shared
* comp region -- the netlist below can't see that distinction, only that
* both devices land on the same py/y nets).
*
* Device sizes must agree with layout/cells/ro_nand2/build.py's
* W_STARVE/L_STARVE/W_PARALLEL/L_SWITCH -- `klt lvs` compares W and L as
* device properties.
*
* Bulk terminals: every cell, ring and block draws an Nwell tap tied to
* `vddr` and a substrate tap tied to `vss` (layout/testcells/gdsii.py's
* `add_taps`; klt >= 0.8.0's `comp.tap_distance.*` requires them), so the
* extractor reports every PMOS bulk as `vddr` and every NMOS bulk as
* `vss` -- the same bulk connections design/xschem/ wires. There is no
* `vsubs` pin and no floating-well net any more.

.SUBCKT ro_nand2 a en y vddr vss
MPH py vss vddr vddr pfet L=2.0U W=0.22U
MPA y a py vddr pfet L=0.28U W=0.44U
MPB y en py vddr pfet L=0.28U W=0.44U
MNA y a nm vss nfet L=0.28U W=0.44U
MNB nm en ny vss nfet L=0.28U W=0.44U
MNT ny vddr vss vss nfet L=2.0U W=0.22U
.ENDS ro_nand2
