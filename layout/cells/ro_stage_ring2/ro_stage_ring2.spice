* ro_stage_ring2 -- LVS reference (schematic-side) netlist.
*
* Hand-written, NOT a copy of `klt extract` output -- see
* layout/testcells/trng_tc_inv.spice for why that distinction matters (an
* LVS run whose reference is the extractor's own output proves nothing).
* This is transcribed directly from design/xschem/ro_stage.sch's four
* devices at ring2's own parameterisation, independent of the layout in
* this directory, and `klt lvs` is asked to agree the drawn geometry
* implements it.
*
* Device topology (design/ro_array_core.spice's `.subckt ro_stage`, at
* ring2's own instantiation `xr2 ... wstv=0.240u lstv=2u` -- ring1's
* ro_stage/ro_stage.spice draws the same topology at wstv=0.220u instead):
*
*   vddr --[Mph: g=vss, W=wstv, L=lstv]-- py --[Mp: g=a, W=0.44, L=0.28]-- y
*   y    --[Mn:  g=a,   W=0.22, L=0.28]-- ny --[Mnt: g=vddr, W=wstv, L=lstv]-- vss
*
* Mph/Mnt are the always-on series "starve" devices (gate tied to the
* opposite rail); Mp/Mn are the switching pair. Device sizes must agree
* with layout/cells/ro_stage_ring2/build.py's W_STARVE/L_STARVE/
* W_SWITCH_P/W_SWITCH_N/L_SWITCH -- `klt lvs` compares W and L as device
* properties.
*
* Bulk terminals: every cell, ring and block draws an Nwell tap tied to
* `vddr` and a substrate tap tied to `vss` (layout/testcells/gdsii.py's
* `add_taps`; klt >= 0.8.0's `comp.tap_distance.*` requires them), so the
* extractor reports every PMOS bulk as `vddr` and every NMOS bulk as
* `vss` -- the same bulk connections design/xschem/ wires. There is no
* `vsubs` pin and no floating-well net any more.

.SUBCKT ro_stage_ring2 a y vddr vss
MPH py vss vddr vddr pfet L=2.0U W=0.24U
MP y a py vddr pfet L=0.28U W=0.44U
MN y a ny vss nfet L=0.28U W=0.22U
MNT ny vddr vss vss nfet L=2.0U W=0.24U
.ENDS ro_stage_ring2
