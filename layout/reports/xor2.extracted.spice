* extracted by klt extract --deck gf180mcu

* cell xor2
* pin a
* pin b
* pin vdd
* pin vss
* pin vsubs
* pin y
.SUBCKT xor2 a b vdd vss vsubs y
* device instance $1 r0 *1 0.8,1 nfet
X$1 \$3 a vss vsubs nfet_03v3 L=0.28U W=0.22U
* device instance $2 r0 *1 3.2,1 nfet
X$2 \$5 b vss vsubs nfet_03v3 L=0.28U W=0.22U
* device instance $3 r0 *1 5.6,1 nfet
X$3 y a \$6 vsubs nfet_03v3 L=0.28U W=0.44U
* device instance $4 r0 *1 8,1 nfet
X$4 \$6 b vss vsubs nfet_03v3 L=0.28U W=0.44U
* device instance $5 r0 *1 10.4,1 nfet
X$5 y \$3 \$8 vsubs nfet_03v3 L=0.28U W=0.44U
* device instance $6 r0 *1 12.8,1 nfet
X$6 \$8 \$5 vss vsubs nfet_03v3 L=0.28U W=0.44U
* device instance $7 r0 *1 17.4,1 pfet
X$7 \$3 a vdd \$11 pfet_03v3 L=0.28U W=0.44U
* device instance $8 r0 *1 19.8,1 pfet
X$8 \$5 b vdd \$11 pfet_03v3 L=0.28U W=0.44U
* device instance $9 r0 *1 22.2,1 pfet
X$9 \$10 a vdd \$11 pfet_03v3 L=0.28U W=0.88U
* device instance $10 r0 *1 24.6,1 pfet
X$10 \$10 b vdd \$11 pfet_03v3 L=0.28U W=0.88U
* device instance $11 r0 *1 27,1 pfet
X$11 y \$3 \$10 \$11 pfet_03v3 L=0.28U W=0.88U
* device instance $12 r0 *1 29.4,1 pfet
X$12 y \$5 \$10 \$11 pfet_03v3 L=0.28U W=0.88U
.ENDS xor2
