* extracted by klt extract --deck gf180mcu

* cell xor2
* pin a
* pin b
* pin vdd
* pin vss
* pin y
.SUBCKT xor2 a b vdd vss y
* device instance $1 r0 *1 0.8,1 nfet
X$1 \$4 a vss vss nfet_03v3 L=0.28U W=0.22U AS=0.3872P AD=0.3872P PS=2.64U
+ PD=2.64U
* device instance $2 r0 *1 3.2,1 nfet
X$2 \$6 b vss vss nfet_03v3 L=0.28U W=0.22U AS=0.3872P AD=0.3872P PS=2.64U
+ PD=2.64U
* device instance $3 r0 *1 5.6,1 nfet
X$3 y a \$7 vss nfet_03v3 L=0.28U W=0.44U AS=0.3872P AD=0.3872P PS=2.64U
+ PD=2.64U
* device instance $4 r0 *1 8,1 nfet
X$4 \$7 b vss vss nfet_03v3 L=0.28U W=0.44U AS=0.3872P AD=0.3872P PS=2.64U
+ PD=2.64U
* device instance $5 r0 *1 10.4,1 nfet
X$5 y \$4 \$9 vss nfet_03v3 L=0.28U W=0.44U AS=0.3872P AD=0.3872P PS=2.64U
+ PD=2.64U
* device instance $6 r0 *1 12.8,1 nfet
X$6 \$9 \$6 vss vss nfet_03v3 L=0.28U W=0.44U AS=0.3872P AD=0.3872P PS=2.64U
+ PD=2.64U
* device instance $7 r0 *1 17.4,1 pfet
X$7 \$4 a vdd vdd pfet_03v3 L=0.28U W=0.44U AS=0.3872P AD=0.3872P PS=2.64U
+ PD=2.64U
* device instance $8 r0 *1 19.8,1 pfet
X$8 \$6 b vdd vdd pfet_03v3 L=0.28U W=0.44U AS=0.3872P AD=0.3872P PS=2.64U
+ PD=2.64U
* device instance $9 r0 *1 22.2,1 pfet
X$9 \$10 a vdd vdd pfet_03v3 L=0.28U W=0.88U AS=0.7744P AD=0.7744P PS=3.52U
+ PD=3.52U
* device instance $10 r0 *1 24.6,1 pfet
X$10 \$10 b vdd vdd pfet_03v3 L=0.28U W=0.88U AS=0.7744P AD=0.7744P PS=3.52U
+ PD=3.52U
* device instance $11 r0 *1 27,1 pfet
X$11 y \$4 \$10 vdd pfet_03v3 L=0.28U W=0.88U AS=0.7744P AD=0.7744P PS=3.52U
+ PD=3.52U
* device instance $12 r0 *1 29.4,1 pfet
X$12 y \$6 \$10 vdd pfet_03v3 L=0.28U W=0.88U AS=0.7744P AD=0.7744P PS=3.52U
+ PD=3.52U
.ENDS xor2
