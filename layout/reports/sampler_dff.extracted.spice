* extracted by klt extract --deck gf180mcu

* cell sampler_dff
* pin clk
* pin d
* pin q
* pin rst_n
* pin vdd
* pin vss
.SUBCKT sampler_dff clk d q rst_n vdd vss
* device instance $1 r0 *1 0.8,1 nfet
X$1 \$3 clk vss vss nfet_03v3 L=0.28U W=0.22U AS=0.3872P AD=0.3872P PS=2.64U
+ PD=2.64U
* device instance $2 r0 *1 3.2,1 nfet
X$2 d \$3 \$4 vss nfet_03v3 L=0.28U W=0.22U AS=0.3872P AD=0.3872P PS=2.64U
+ PD=2.64U
* device instance $3 r0 *1 5.6,1 nfet
X$3 \$6 \$13 vss vss nfet_03v3 L=0.28U W=0.22U AS=0.3872P AD=0.3872P PS=2.64U
+ PD=2.64U
* device instance $4 r0 *1 8,1 nfet
X$4 \$6 clk \$4 vss nfet_03v3 L=0.28U W=0.22U AS=0.3872P AD=0.3872P PS=2.64U
+ PD=2.64U
* device instance $5 r0 *1 10.4,1 nfet
X$5 \$13 clk \$7 vss nfet_03v3 L=0.28U W=0.22U AS=0.3872P AD=0.3872P PS=2.64U
+ PD=2.64U
* device instance $6 r0 *1 12.8,1 nfet
X$6 q \$7 vss vss nfet_03v3 L=0.28U W=0.22U AS=0.3872P AD=0.3872P PS=2.64U
+ PD=2.64U
* device instance $7 r0 *1 15.2,1 nfet
X$7 \$9 \$3 \$7 vss nfet_03v3 L=0.28U W=0.22U AS=0.3872P AD=0.3872P PS=2.64U
+ PD=2.64U
* device instance $8 r0 *1 17.6,1 nfet
X$8 \$13 \$4 \$10 vss nfet_03v3 L=0.28U W=0.44U AS=0.3872P AD=0.3872P PS=2.64U
+ PD=2.64U
* device instance $9 r0 *1 20,1 nfet
X$9 \$10 rst_n vss vss nfet_03v3 L=0.28U W=0.44U AS=0.3872P AD=0.3872P PS=2.64U
+ PD=2.64U
* device instance $10 r0 *1 22.4,1 nfet
X$10 \$9 q \$11 vss nfet_03v3 L=0.28U W=0.44U AS=0.3872P AD=0.3872P PS=2.64U
+ PD=2.64U
* device instance $11 r0 *1 24.8,1 nfet
X$11 \$11 rst_n vss vss nfet_03v3 L=0.28U W=0.44U AS=0.3872P AD=0.3872P
+ PS=2.64U PD=2.64U
* device instance $12 r0 *1 29.4,1 pfet
X$12 \$3 clk vdd vdd pfet_03v3 L=0.28U W=0.44U AS=0.3872P AD=0.3872P PS=2.64U
+ PD=2.64U
* device instance $13 r0 *1 31.8,1 pfet
X$13 d clk \$4 vdd pfet_03v3 L=0.28U W=0.44U AS=0.3872P AD=0.3872P PS=2.64U
+ PD=2.64U
* device instance $14 r0 *1 34.2,1 pfet
X$14 \$13 \$4 vdd vdd pfet_03v3 L=0.28U W=0.44U AS=0.3872P AD=0.3872P PS=2.64U
+ PD=2.64U
* device instance $15 r0 *1 36.6,1 pfet
X$15 \$13 rst_n vdd vdd pfet_03v3 L=0.28U W=0.44U AS=0.3872P AD=0.3872P
+ PS=2.64U PD=2.64U
* device instance $16 r0 *1 39,1 pfet
X$16 \$6 \$13 vdd vdd pfet_03v3 L=0.28U W=0.44U AS=0.3872P AD=0.3872P PS=2.64U
+ PD=2.64U
* device instance $17 r0 *1 41.4,1 pfet
X$17 \$6 \$3 \$4 vdd pfet_03v3 L=0.28U W=0.44U AS=0.3872P AD=0.3872P PS=2.64U
+ PD=2.64U
* device instance $18 r0 *1 43.8,1 pfet
X$18 \$13 \$3 \$7 vdd pfet_03v3 L=0.28U W=0.44U AS=0.3872P AD=0.3872P PS=2.64U
+ PD=2.64U
* device instance $19 r0 *1 46.2,1 pfet
X$19 q \$7 vdd vdd pfet_03v3 L=0.28U W=0.44U AS=0.3872P AD=0.3872P PS=2.64U
+ PD=2.64U
* device instance $20 r0 *1 48.6,1 pfet
X$20 \$9 q vdd vdd pfet_03v3 L=0.28U W=0.44U AS=0.3872P AD=0.3872P PS=2.64U
+ PD=2.64U
* device instance $21 r0 *1 51,1 pfet
X$21 \$9 rst_n vdd vdd pfet_03v3 L=0.28U W=0.44U AS=0.3872P AD=0.3872P PS=2.64U
+ PD=2.64U
* device instance $22 r0 *1 53.4,1 pfet
X$22 \$9 clk \$7 vdd pfet_03v3 L=0.28U W=0.44U AS=0.3872P AD=0.3872P PS=2.64U
+ PD=2.64U
.ENDS sampler_dff
