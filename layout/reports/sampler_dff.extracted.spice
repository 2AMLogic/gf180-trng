* extracted by klt extract --deck gf180mcu

* cell sampler_dff
* pin clk
* pin d
* pin q
* pin rst_n
* pin vdd
* pin vss
* pin vsubs
.SUBCKT sampler_dff clk d q rst_n vdd vss vsubs
* device instance $1 r0 *1 0.8,1 nfet
X$1 \$2 clk vss vsubs nfet_03v3 L=0.28U W=0.22U AS=0.3872P AD=0.3872P PS=2.64U
+ PD=2.64U
* device instance $2 r0 *1 3.2,1 nfet
X$2 d \$2 \$3 vsubs nfet_03v3 L=0.28U W=0.22U AS=0.3872P AD=0.3872P PS=2.64U
+ PD=2.64U
* device instance $3 r0 *1 5.6,1 nfet
X$3 \$5 \$13 vss vsubs nfet_03v3 L=0.28U W=0.22U AS=0.3872P AD=0.3872P PS=2.64U
+ PD=2.64U
* device instance $4 r0 *1 8,1 nfet
X$4 \$5 clk \$3 vsubs nfet_03v3 L=0.28U W=0.22U AS=0.3872P AD=0.3872P PS=2.64U
+ PD=2.64U
* device instance $5 r0 *1 10.4,1 nfet
X$5 \$13 clk \$6 vsubs nfet_03v3 L=0.28U W=0.22U AS=0.3872P AD=0.3872P PS=2.64U
+ PD=2.64U
* device instance $6 r0 *1 12.8,1 nfet
X$6 q \$6 vss vsubs nfet_03v3 L=0.28U W=0.22U AS=0.3872P AD=0.3872P PS=2.64U
+ PD=2.64U
* device instance $7 r0 *1 15.2,1 nfet
X$7 \$8 \$2 \$6 vsubs nfet_03v3 L=0.28U W=0.22U AS=0.3872P AD=0.3872P PS=2.64U
+ PD=2.64U
* device instance $8 r0 *1 17.6,1 nfet
X$8 \$13 \$3 \$9 vsubs nfet_03v3 L=0.28U W=0.44U AS=0.3872P AD=0.3872P PS=2.64U
+ PD=2.64U
* device instance $9 r0 *1 20,1 nfet
X$9 \$9 rst_n vss vsubs nfet_03v3 L=0.28U W=0.44U AS=0.3872P AD=0.3872P
+ PS=2.64U PD=2.64U
* device instance $10 r0 *1 22.4,1 nfet
X$10 \$8 q \$10 vsubs nfet_03v3 L=0.28U W=0.44U AS=0.3872P AD=0.3872P PS=2.64U
+ PD=2.64U
* device instance $11 r0 *1 24.8,1 nfet
X$11 \$10 rst_n vss vsubs nfet_03v3 L=0.28U W=0.44U AS=0.3872P AD=0.3872P
+ PS=2.64U PD=2.64U
* device instance $12 r0 *1 29.4,1 pfet
X$12 \$2 clk vdd \$15 pfet_03v3 L=0.28U W=0.44U AS=0.3872P AD=0.3872P PS=2.64U
+ PD=2.64U
* device instance $13 r0 *1 31.8,1 pfet
X$13 d clk \$3 \$15 pfet_03v3 L=0.28U W=0.44U AS=0.3872P AD=0.3872P PS=2.64U
+ PD=2.64U
* device instance $14 r0 *1 34.2,1 pfet
X$14 \$13 \$3 vdd \$15 pfet_03v3 L=0.28U W=0.44U AS=0.3872P AD=0.3872P PS=2.64U
+ PD=2.64U
* device instance $15 r0 *1 36.6,1 pfet
X$15 \$13 rst_n vdd \$15 pfet_03v3 L=0.28U W=0.44U AS=0.3872P AD=0.3872P
+ PS=2.64U PD=2.64U
* device instance $16 r0 *1 39,1 pfet
X$16 \$5 \$13 vdd \$15 pfet_03v3 L=0.28U W=0.44U AS=0.3872P AD=0.3872P PS=2.64U
+ PD=2.64U
* device instance $17 r0 *1 41.4,1 pfet
X$17 \$5 \$2 \$3 \$15 pfet_03v3 L=0.28U W=0.44U AS=0.3872P AD=0.3872P PS=2.64U
+ PD=2.64U
* device instance $18 r0 *1 43.8,1 pfet
X$18 \$13 \$2 \$6 \$15 pfet_03v3 L=0.28U W=0.44U AS=0.3872P AD=0.3872P PS=2.64U
+ PD=2.64U
* device instance $19 r0 *1 46.2,1 pfet
X$19 q \$6 vdd \$15 pfet_03v3 L=0.28U W=0.44U AS=0.3872P AD=0.3872P PS=2.64U
+ PD=2.64U
* device instance $20 r0 *1 48.6,1 pfet
X$20 \$8 q vdd \$15 pfet_03v3 L=0.28U W=0.44U AS=0.3872P AD=0.3872P PS=2.64U
+ PD=2.64U
* device instance $21 r0 *1 51,1 pfet
X$21 \$8 rst_n vdd \$15 pfet_03v3 L=0.28U W=0.44U AS=0.3872P AD=0.3872P
+ PS=2.64U PD=2.64U
* device instance $22 r0 *1 53.4,1 pfet
X$22 \$8 clk \$6 \$15 pfet_03v3 L=0.28U W=0.44U AS=0.3872P AD=0.3872P PS=2.64U
+ PD=2.64U
.ENDS sampler_dff
