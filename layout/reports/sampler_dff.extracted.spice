* extracted by klt extract --deck gf180mcu

* cell sampler_dff
* pin clk
* pin d
* pin q
* pin rst_n
* pin vdd
* pin vss
* pin vsubs
.SUBCKT sampler_dff clk d q rst_n vdd vss vsubs
* device instance $1 r0 *1 0.8,1 nfet
X$1 \$4 clk vss vsubs nfet_03v3 L=0.28U W=0.22U AS=0.3872P AD=0.3872P PS=2.64U
+ PD=2.64U
* device instance $2 r0 *1 3.2,1 nfet
X$2 d \$4 \$5 vsubs nfet_03v3 L=0.28U W=0.22U AS=0.3872P AD=0.3872P PS=2.64U
+ PD=2.64U
* device instance $3 r0 *1 5.6,1 nfet
X$3 \$8 \$7 vss vsubs nfet_03v3 L=0.28U W=0.22U AS=0.3872P AD=0.3872P PS=2.64U
+ PD=2.64U
* device instance $4 r0 *1 8,1 nfet
X$4 \$8 clk \$5 vsubs nfet_03v3 L=0.28U W=0.22U AS=0.3872P AD=0.3872P PS=2.64U
+ PD=2.64U
* device instance $5 r0 *1 10.4,1 nfet
X$5 \$7 clk \$9 vsubs nfet_03v3 L=0.28U W=0.22U AS=0.3872P AD=0.3872P PS=2.64U
+ PD=2.64U
* device instance $6 r0 *1 12.8,1 nfet
X$6 q \$9 vss vsubs nfet_03v3 L=0.28U W=0.22U AS=0.3872P AD=0.3872P PS=2.64U
+ PD=2.64U
* device instance $7 r0 *1 15.2,1 nfet
X$7 \$11 \$4 \$9 vsubs nfet_03v3 L=0.28U W=0.22U AS=0.3872P AD=0.3872P PS=2.64U
+ PD=2.64U
* device instance $8 r0 *1 17.6,1 nfet
X$8 \$7 \$5 \$12 vsubs nfet_03v3 L=0.28U W=0.44U AS=0.3872P AD=0.3872P PS=2.64U
+ PD=2.64U
* device instance $9 r0 *1 20,1 nfet
X$9 \$12 rst_n vss vsubs nfet_03v3 L=0.28U W=0.44U AS=0.3872P AD=0.3872P
+ PS=2.64U PD=2.64U
* device instance $10 r0 *1 22.4,1 nfet
X$10 \$11 q \$13 vsubs nfet_03v3 L=0.28U W=0.44U AS=0.3872P AD=0.3872P PS=2.64U
+ PD=2.64U
* device instance $11 r0 *1 24.8,1 nfet
X$11 \$13 rst_n vss vsubs nfet_03v3 L=0.28U W=0.44U AS=0.3872P AD=0.3872P
+ PS=2.64U PD=2.64U
* device instance $12 r0 *1 29.4,1 pfet
X$12 \$4 clk vdd \$15 pfet_03v3 L=0.28U W=0.44U AS=0.3872P AD=0.3872P PS=2.64U
+ PD=2.64U
* device instance $13 r0 *1 31.8,1 pfet
X$13 d clk \$5 \$15 pfet_03v3 L=0.28U W=0.44U AS=0.3872P AD=0.3872P PS=2.64U
+ PD=2.64U
* device instance $14 r0 *1 34.2,1 pfet
X$14 \$7 \$5 vdd \$15 pfet_03v3 L=0.28U W=0.44U AS=0.3872P AD=0.3872P PS=2.64U
+ PD=2.64U
* device instance $15 r0 *1 36.6,1 pfet
X$15 \$7 rst_n vdd \$15 pfet_03v3 L=0.28U W=0.44U AS=0.3872P AD=0.3872P
+ PS=2.64U PD=2.64U
* device instance $16 r0 *1 39,1 pfet
X$16 \$8 \$7 vdd \$15 pfet_03v3 L=0.28U W=0.44U AS=0.3872P AD=0.3872P PS=2.64U
+ PD=2.64U
* device instance $17 r0 *1 41.4,1 pfet
X$17 \$8 \$4 \$5 \$15 pfet_03v3 L=0.28U W=0.44U AS=0.3872P AD=0.3872P PS=2.64U
+ PD=2.64U
* device instance $18 r0 *1 43.8,1 pfet
X$18 \$7 \$4 \$9 \$15 pfet_03v3 L=0.28U W=0.44U AS=0.3872P AD=0.3872P PS=2.64U
+ PD=2.64U
* device instance $19 r0 *1 46.2,1 pfet
X$19 q \$9 vdd \$15 pfet_03v3 L=0.28U W=0.44U AS=0.3872P AD=0.3872P PS=2.64U
+ PD=2.64U
* device instance $20 r0 *1 48.6,1 pfet
X$20 \$11 q vdd \$15 pfet_03v3 L=0.28U W=0.44U AS=0.3872P AD=0.3872P PS=2.64U
+ PD=2.64U
* device instance $21 r0 *1 51,1 pfet
X$21 \$11 rst_n vdd \$15 pfet_03v3 L=0.28U W=0.44U AS=0.3872P AD=0.3872P
+ PS=2.64U PD=2.64U
* device instance $22 r0 *1 53.4,1 pfet
X$22 \$11 clk \$9 \$15 pfet_03v3 L=0.28U W=0.44U AS=0.3872P AD=0.3872P PS=2.64U
+ PD=2.64U
.ENDS sampler_dff
