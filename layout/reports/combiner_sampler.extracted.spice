* extracted by klt extract --deck gf180mcu

* cell combiner_sampler
* pin a,d
* pin b,d
* pin clk
* pin d,vdd
* pin d,y
* pin q
* pin q
* pin q
* pin q
* pin rst_n
* pin vss
* pin vsubs
.SUBCKT combiner_sampler a|d b|d clk d|vdd d|y q q$1 q$2 q$3 rst_n vss vsubs
* device instance $1 r0 *1 5.6,1 nfet
X$1 d|y a|d \$5 vsubs nfet_03v3 L=0.28U W=0.44U
* device instance $2 r0 *1 8,1 nfet
X$2 \$5 b|d vss vsubs nfet_03v3 L=0.28U W=0.44U
* device instance $3 r0 *1 10.4,1 nfet
X$3 d|y \$3 \$7 vsubs nfet_03v3 L=0.28U W=0.44U
* device instance $4 r0 *1 12.8,1 nfet
X$4 \$7 \$4 vss vsubs nfet_03v3 L=0.28U W=0.44U
* device instance $5 r0 *1 54.49,1 nfet
X$5 \$13 \$12 \$18 vsubs nfet_03v3 L=0.28U W=0.44U
* device instance $6 r0 *1 56.89,1 nfet
X$6 \$18 rst_n vss vsubs nfet_03v3 L=0.28U W=0.44U
* device instance $7 r0 *1 59.29,1 nfet
X$7 \$17 q \$19 vsubs nfet_03v3 L=0.28U W=0.44U
* device instance $8 r0 *1 61.69,1 nfet
X$8 \$19 rst_n vss vsubs nfet_03v3 L=0.28U W=0.44U
* device instance $9 r0 *1 115.38,1 nfet
X$9 \$23 \$22 \$28 vsubs nfet_03v3 L=0.28U W=0.44U
* device instance $10 r0 *1 117.78,1 nfet
X$10 \$28 rst_n vss vsubs nfet_03v3 L=0.28U W=0.44U
* device instance $11 r0 *1 120.18,1 nfet
X$11 \$27 q$1 \$29 vsubs nfet_03v3 L=0.28U W=0.44U
* device instance $12 r0 *1 122.58,1 nfet
X$12 \$29 rst_n vss vsubs nfet_03v3 L=0.28U W=0.44U
* device instance $13 r0 *1 176.27,1 nfet
X$13 \$47 \$31 \$36 vsubs nfet_03v3 L=0.28U W=0.44U
* device instance $14 r0 *1 178.67,1 nfet
X$14 \$36 rst_n vss vsubs nfet_03v3 L=0.28U W=0.44U
* device instance $15 r0 *1 181.07,1 nfet
X$15 \$35 q$2 \$37 vsubs nfet_03v3 L=0.28U W=0.44U
* device instance $16 r0 *1 183.47,1 nfet
X$16 \$37 rst_n vss vsubs nfet_03v3 L=0.28U W=0.44U
* device instance $17 r0 *1 237.16,1 nfet
X$17 \$48 \$39 \$44 vsubs nfet_03v3 L=0.28U W=0.44U
* device instance $18 r0 *1 239.56,1 nfet
X$18 \$44 rst_n vss vsubs nfet_03v3 L=0.28U W=0.44U
* device instance $19 r0 *1 241.96,1 nfet
X$19 \$43 q$3 \$45 vsubs nfet_03v3 L=0.28U W=0.44U
* device instance $20 r0 *1 244.36,1 nfet
X$20 \$45 rst_n vss vsubs nfet_03v3 L=0.28U W=0.44U
* device instance $21 r0 *1 0.8,1 nfet
X$21 \$3 a|d vss vsubs nfet_03v3 L=0.28U W=0.22U
* device instance $22 r0 *1 3.2,1 nfet
X$22 \$4 b|d vss vsubs nfet_03v3 L=0.28U W=0.22U
* device instance $23 r0 *1 37.69,1 nfet
X$23 \$11 clk vss vsubs nfet_03v3 L=0.28U W=0.22U
* device instance $24 r0 *1 40.09,1 nfet
X$24 d|y \$11 \$12 vsubs nfet_03v3 L=0.28U W=0.22U
* device instance $25 r0 *1 42.49,1 nfet
X$25 \$14 \$13 vss vsubs nfet_03v3 L=0.28U W=0.22U
* device instance $26 r0 *1 44.89,1 nfet
X$26 \$14 clk \$12 vsubs nfet_03v3 L=0.28U W=0.22U
* device instance $27 r0 *1 47.29,1 nfet
X$27 \$13 clk \$15 vsubs nfet_03v3 L=0.28U W=0.22U
* device instance $28 r0 *1 49.69,1 nfet
X$28 q \$15 vss vsubs nfet_03v3 L=0.28U W=0.22U
* device instance $29 r0 *1 52.09,1 nfet
X$29 \$17 \$11 \$15 vsubs nfet_03v3 L=0.28U W=0.22U
* device instance $30 r0 *1 98.58,1 nfet
X$30 \$21 clk vss vsubs nfet_03v3 L=0.28U W=0.22U
* device instance $31 r0 *1 100.98,1 nfet
X$31 d|vdd \$21 \$22 vsubs nfet_03v3 L=0.28U W=0.22U
* device instance $32 r0 *1 103.38,1 nfet
X$32 \$24 \$23 vss vsubs nfet_03v3 L=0.28U W=0.22U
* device instance $33 r0 *1 105.78,1 nfet
X$33 \$24 clk \$22 vsubs nfet_03v3 L=0.28U W=0.22U
* device instance $34 r0 *1 108.18,1 nfet
X$34 \$23 clk \$25 vsubs nfet_03v3 L=0.28U W=0.22U
* device instance $35 r0 *1 110.58,1 nfet
X$35 q$1 \$25 vss vsubs nfet_03v3 L=0.28U W=0.22U
* device instance $36 r0 *1 112.98,1 nfet
X$36 \$27 \$21 \$25 vsubs nfet_03v3 L=0.28U W=0.22U
* device instance $37 r0 *1 159.47,1 nfet
X$37 \$30 clk vss vsubs nfet_03v3 L=0.28U W=0.22U
* device instance $38 r0 *1 161.87,1 nfet
X$38 a|d \$30 \$31 vsubs nfet_03v3 L=0.28U W=0.22U
* device instance $39 r0 *1 164.27,1 nfet
X$39 \$32 \$47 vss vsubs nfet_03v3 L=0.28U W=0.22U
* device instance $40 r0 *1 166.67,1 nfet
X$40 \$32 clk \$31 vsubs nfet_03v3 L=0.28U W=0.22U
* device instance $41 r0 *1 169.07,1 nfet
X$41 \$47 clk \$33 vsubs nfet_03v3 L=0.28U W=0.22U
* device instance $42 r0 *1 171.47,1 nfet
X$42 q$2 \$33 vss vsubs nfet_03v3 L=0.28U W=0.22U
* device instance $43 r0 *1 173.87,1 nfet
X$43 \$35 \$30 \$33 vsubs nfet_03v3 L=0.28U W=0.22U
* device instance $44 r0 *1 220.36,1 nfet
X$44 \$38 clk vss vsubs nfet_03v3 L=0.28U W=0.22U
* device instance $45 r0 *1 222.76,1 nfet
X$45 b|d \$38 \$39 vsubs nfet_03v3 L=0.28U W=0.22U
* device instance $46 r0 *1 225.16,1 nfet
X$46 \$40 \$48 vss vsubs nfet_03v3 L=0.28U W=0.22U
* device instance $47 r0 *1 227.56,1 nfet
X$47 \$40 clk \$39 vsubs nfet_03v3 L=0.28U W=0.22U
* device instance $48 r0 *1 229.96,1 nfet
X$48 \$48 clk \$41 vsubs nfet_03v3 L=0.28U W=0.22U
* device instance $49 r0 *1 232.36,1 nfet
X$49 q$3 \$41 vss vsubs nfet_03v3 L=0.28U W=0.22U
* device instance $50 r0 *1 234.76,1 nfet
X$50 \$43 \$38 \$41 vsubs nfet_03v3 L=0.28U W=0.22U
* device instance $51 r0 *1 22.2,1 pfet
X$51 \$8 a|d d|vdd \$49 pfet_03v3 L=0.28U W=0.88U
* device instance $52 r0 *1 24.6,1 pfet
X$52 \$8 b|d d|vdd \$49 pfet_03v3 L=0.28U W=0.88U
* device instance $53 r0 *1 27,1 pfet
X$53 d|y \$3 \$8 \$49 pfet_03v3 L=0.28U W=0.88U
* device instance $54 r0 *1 29.4,1 pfet
X$54 d|y \$4 \$8 \$49 pfet_03v3 L=0.28U W=0.88U
* device instance $55 r0 *1 17.4,1 pfet
X$55 \$3 a|d d|vdd \$49 pfet_03v3 L=0.28U W=0.44U
* device instance $56 r0 *1 19.8,1 pfet
X$56 \$4 b|d d|vdd \$49 pfet_03v3 L=0.28U W=0.44U
* device instance $57 r0 *1 66.29,1 pfet
X$57 \$11 clk d|vdd \$50 pfet_03v3 L=0.28U W=0.44U
* device instance $58 r0 *1 68.69,1 pfet
X$58 d|y clk \$12 \$50 pfet_03v3 L=0.28U W=0.44U
* device instance $59 r0 *1 71.09,1 pfet
X$59 \$13 \$12 d|vdd \$50 pfet_03v3 L=0.28U W=0.44U
* device instance $60 r0 *1 73.49,1 pfet
X$60 \$13 rst_n d|vdd \$50 pfet_03v3 L=0.28U W=0.44U
* device instance $61 r0 *1 75.89,1 pfet
X$61 \$14 \$13 d|vdd \$50 pfet_03v3 L=0.28U W=0.44U
* device instance $62 r0 *1 78.29,1 pfet
X$62 \$14 \$11 \$12 \$50 pfet_03v3 L=0.28U W=0.44U
* device instance $63 r0 *1 80.69,1 pfet
X$63 \$13 \$11 \$15 \$50 pfet_03v3 L=0.28U W=0.44U
* device instance $64 r0 *1 83.09,1 pfet
X$64 q \$15 d|vdd \$50 pfet_03v3 L=0.28U W=0.44U
* device instance $65 r0 *1 85.49,1 pfet
X$65 \$17 q d|vdd \$50 pfet_03v3 L=0.28U W=0.44U
* device instance $66 r0 *1 87.89,1 pfet
X$66 \$17 rst_n d|vdd \$50 pfet_03v3 L=0.28U W=0.44U
* device instance $67 r0 *1 90.29,1 pfet
X$67 \$17 clk \$15 \$50 pfet_03v3 L=0.28U W=0.44U
* device instance $68 r0 *1 127.18,1 pfet
X$68 \$21 clk d|vdd \$51 pfet_03v3 L=0.28U W=0.44U
* device instance $69 r0 *1 129.58,1 pfet
X$69 d|vdd clk \$22 \$51 pfet_03v3 L=0.28U W=0.44U
* device instance $70 r0 *1 131.98,1 pfet
X$70 \$23 \$22 d|vdd \$51 pfet_03v3 L=0.28U W=0.44U
* device instance $71 r0 *1 134.38,1 pfet
X$71 \$23 rst_n d|vdd \$51 pfet_03v3 L=0.28U W=0.44U
* device instance $72 r0 *1 136.78,1 pfet
X$72 \$24 \$23 d|vdd \$51 pfet_03v3 L=0.28U W=0.44U
* device instance $73 r0 *1 139.18,1 pfet
X$73 \$24 \$21 \$22 \$51 pfet_03v3 L=0.28U W=0.44U
* device instance $74 r0 *1 141.58,1 pfet
X$74 \$23 \$21 \$25 \$51 pfet_03v3 L=0.28U W=0.44U
* device instance $75 r0 *1 143.98,1 pfet
X$75 q$1 \$25 d|vdd \$51 pfet_03v3 L=0.28U W=0.44U
* device instance $76 r0 *1 146.38,1 pfet
X$76 \$27 q$1 d|vdd \$51 pfet_03v3 L=0.28U W=0.44U
* device instance $77 r0 *1 148.78,1 pfet
X$77 \$27 rst_n d|vdd \$51 pfet_03v3 L=0.28U W=0.44U
* device instance $78 r0 *1 151.18,1 pfet
X$78 \$27 clk \$25 \$51 pfet_03v3 L=0.28U W=0.44U
* device instance $79 r0 *1 188.07,1 pfet
X$79 \$30 clk d|vdd \$52 pfet_03v3 L=0.28U W=0.44U
* device instance $80 r0 *1 190.47,1 pfet
X$80 a|d clk \$31 \$52 pfet_03v3 L=0.28U W=0.44U
* device instance $81 r0 *1 192.87,1 pfet
X$81 \$47 \$31 d|vdd \$52 pfet_03v3 L=0.28U W=0.44U
* device instance $82 r0 *1 195.27,1 pfet
X$82 \$47 rst_n d|vdd \$52 pfet_03v3 L=0.28U W=0.44U
* device instance $83 r0 *1 197.67,1 pfet
X$83 \$32 \$47 d|vdd \$52 pfet_03v3 L=0.28U W=0.44U
* device instance $84 r0 *1 200.07,1 pfet
X$84 \$32 \$30 \$31 \$52 pfet_03v3 L=0.28U W=0.44U
* device instance $85 r0 *1 202.47,1 pfet
X$85 \$47 \$30 \$33 \$52 pfet_03v3 L=0.28U W=0.44U
* device instance $86 r0 *1 204.87,1 pfet
X$86 q$2 \$33 d|vdd \$52 pfet_03v3 L=0.28U W=0.44U
* device instance $87 r0 *1 207.27,1 pfet
X$87 \$35 q$2 d|vdd \$52 pfet_03v3 L=0.28U W=0.44U
* device instance $88 r0 *1 209.67,1 pfet
X$88 \$35 rst_n d|vdd \$52 pfet_03v3 L=0.28U W=0.44U
* device instance $89 r0 *1 212.07,1 pfet
X$89 \$35 clk \$33 \$52 pfet_03v3 L=0.28U W=0.44U
* device instance $90 r0 *1 248.96,1 pfet
X$90 \$38 clk d|vdd \$53 pfet_03v3 L=0.28U W=0.44U
* device instance $91 r0 *1 251.36,1 pfet
X$91 b|d clk \$39 \$53 pfet_03v3 L=0.28U W=0.44U
* device instance $92 r0 *1 253.76,1 pfet
X$92 \$48 \$39 d|vdd \$53 pfet_03v3 L=0.28U W=0.44U
* device instance $93 r0 *1 256.16,1 pfet
X$93 \$48 rst_n d|vdd \$53 pfet_03v3 L=0.28U W=0.44U
* device instance $94 r0 *1 258.56,1 pfet
X$94 \$40 \$48 d|vdd \$53 pfet_03v3 L=0.28U W=0.44U
* device instance $95 r0 *1 260.96,1 pfet
X$95 \$40 \$38 \$39 \$53 pfet_03v3 L=0.28U W=0.44U
* device instance $96 r0 *1 263.36,1 pfet
X$96 \$48 \$38 \$41 \$53 pfet_03v3 L=0.28U W=0.44U
* device instance $97 r0 *1 265.76,1 pfet
X$97 q$3 \$41 d|vdd \$53 pfet_03v3 L=0.28U W=0.44U
* device instance $98 r0 *1 268.16,1 pfet
X$98 \$43 q$3 d|vdd \$53 pfet_03v3 L=0.28U W=0.44U
* device instance $99 r0 *1 270.56,1 pfet
X$99 \$43 rst_n d|vdd \$53 pfet_03v3 L=0.28U W=0.44U
* device instance $100 r0 *1 272.96,1 pfet
X$100 \$43 clk \$41 \$53 pfet_03v3 L=0.28U W=0.44U
.ENDS combiner_sampler
