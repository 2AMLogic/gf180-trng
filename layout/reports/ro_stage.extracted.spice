* extracted by klt extract --deck gf180mcu

* cell ro_stage
* pin a
* pin vddr
* pin vss
* pin vsubs
* pin y
.SUBCKT ro_stage a vddr vss vsubs y
* device instance $1 r0 *1 0.84,0.22 nfet
X$1 \$5 a y vsubs nfet_03v3 L=0.28U W=0.22U AS=0.308P AD=0.044P PS=2.28U
+ PD=0.62U
* device instance $2 r0 *1 2.38,0.22 nfet
X$2 \$5 vddr vss vsubs nfet_03v3 L=2U W=0.22U AS=0.308P AD=0.044P PS=2.28U
+ PD=0.62U
* device instance $3 r0 *1 2.38,1.86 pfet
X$3 vddr vss \$6 \$7 pfet_03v3 L=2U W=0.22U AS=0.088P AD=0.308P PS=0.84U
+ PD=2.28U
* device instance $4 r0 *1 0.84,1.86 pfet
X$4 \$6 a y \$7 pfet_03v3 L=0.28U W=0.44U AS=0.308P AD=0.088P PS=2.28U PD=0.84U
.ENDS ro_stage
