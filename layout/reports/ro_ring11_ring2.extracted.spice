* extracted by klt extract --deck gf180mcu

* cell ro_ring11_ring2
* pin a,y
* pin a,y
* pin a,y
* pin a,y
* pin a,y
* pin a,y
* pin a,y
* pin a,y
* pin a,y
* pin a,y
* pin a,y
* pin en
* pin vddr
* pin vss
.SUBCKT ro_ring11_ring2 a|y a|y$1 a|y$2 a|y$3 a|y$4 a|y$5 a|y$6 a|y$7 a|y$8
+ a|y$9 a|y$10 en vddr vss
* device instance $1 r0 *1 3.86,0.22 nfet
X$1 vss vddr \$15 vss nfet_03v3 L=2U W=0.24U AS=0.176P AD=0.308P PS=1.24U
+ PD=2.28U
* device instance $2 r0 *1 0.84,0.22 nfet
X$2 \$14 a|y$10 a|y vss nfet_03v3 L=0.28U W=0.44U AS=0.308P AD=0.176P PS=2.28U
+ PD=1.24U
* device instance $3 r0 *1 1.92,0.22 nfet
X$3 \$15 en \$14 vss nfet_03v3 L=0.28U W=0.44U AS=0.176P AD=0.176P PS=1.24U
+ PD=1.24U
* device instance $4 r0 *1 10.14,0.22 nfet
X$4 \$17 a|y a|y$1 vss nfet_03v3 L=0.28U W=0.22U AS=0.308P AD=0.088P PS=2.28U
+ PD=0.84U
* device instance $5 r0 *1 11.68,0.22 nfet
X$5 vss vddr \$17 vss nfet_03v3 L=2U W=0.24U AS=0.088P AD=0.308P PS=0.84U
+ PD=2.28U
* device instance $6 r0 *1 18.21,0.22 nfet
X$6 \$18 a|y$1 a|y$2 vss nfet_03v3 L=0.28U W=0.22U AS=0.308P AD=0.088P PS=2.28U
+ PD=0.84U
* device instance $7 r0 *1 19.75,0.22 nfet
X$7 vss vddr \$18 vss nfet_03v3 L=2U W=0.24U AS=0.088P AD=0.308P PS=0.84U
+ PD=2.28U
* device instance $8 r0 *1 26.28,0.22 nfet
X$8 \$20 a|y$2 a|y$3 vss nfet_03v3 L=0.28U W=0.22U AS=0.308P AD=0.088P PS=2.28U
+ PD=0.84U
* device instance $9 r0 *1 27.82,0.22 nfet
X$9 vss vddr \$20 vss nfet_03v3 L=2U W=0.24U AS=0.088P AD=0.308P PS=0.84U
+ PD=2.28U
* device instance $10 r0 *1 34.35,0.22 nfet
X$10 \$22 a|y$3 a|y$4 vss nfet_03v3 L=0.28U W=0.22U AS=0.308P AD=0.088P
+ PS=2.28U PD=0.84U
* device instance $11 r0 *1 35.89,0.22 nfet
X$11 vss vddr \$22 vss nfet_03v3 L=2U W=0.24U AS=0.088P AD=0.308P PS=0.84U
+ PD=2.28U
* device instance $12 r0 *1 42.42,0.22 nfet
X$12 \$23 a|y$4 a|y$5 vss nfet_03v3 L=0.28U W=0.22U AS=0.308P AD=0.088P
+ PS=2.28U PD=0.84U
* device instance $13 r0 *1 43.96,0.22 nfet
X$13 vss vddr \$23 vss nfet_03v3 L=2U W=0.24U AS=0.088P AD=0.308P PS=0.84U
+ PD=2.28U
* device instance $14 r0 *1 50.49,0.22 nfet
X$14 \$25 a|y$5 a|y$6 vss nfet_03v3 L=0.28U W=0.22U AS=0.308P AD=0.088P
+ PS=2.28U PD=0.84U
* device instance $15 r0 *1 52.03,0.22 nfet
X$15 vss vddr \$25 vss nfet_03v3 L=2U W=0.24U AS=0.088P AD=0.308P PS=0.84U
+ PD=2.28U
* device instance $16 r0 *1 58.56,0.22 nfet
X$16 \$24 a|y$6 a|y$7 vss nfet_03v3 L=0.28U W=0.22U AS=0.308P AD=0.088P
+ PS=2.28U PD=0.84U
* device instance $17 r0 *1 60.1,0.22 nfet
X$17 vss vddr \$24 vss nfet_03v3 L=2U W=0.24U AS=0.088P AD=0.308P PS=0.84U
+ PD=2.28U
* device instance $18 r0 *1 66.63,0.22 nfet
X$18 \$21 a|y$7 a|y$8 vss nfet_03v3 L=0.28U W=0.22U AS=0.308P AD=0.088P
+ PS=2.28U PD=0.84U
* device instance $19 r0 *1 68.17,0.22 nfet
X$19 vss vddr \$21 vss nfet_03v3 L=2U W=0.24U AS=0.088P AD=0.308P PS=0.84U
+ PD=2.28U
* device instance $20 r0 *1 74.7,0.22 nfet
X$20 \$19 a|y$8 a|y$9 vss nfet_03v3 L=0.28U W=0.22U AS=0.308P AD=0.088P
+ PS=2.28U PD=0.84U
* device instance $21 r0 *1 76.24,0.22 nfet
X$21 vss vddr \$19 vss nfet_03v3 L=2U W=0.24U AS=0.088P AD=0.308P PS=0.84U
+ PD=2.28U
* device instance $22 r0 *1 82.77,0.22 nfet
X$22 \$16 a|y$9 a|y$10 vss nfet_03v3 L=0.28U W=0.22U AS=0.308P AD=0.088P
+ PS=2.28U PD=0.84U
* device instance $23 r0 *1 84.31,0.22 nfet
X$23 vss vddr \$16 vss nfet_03v3 L=2U W=0.24U AS=0.088P AD=0.308P PS=0.84U
+ PD=2.28U
* device instance $24 r0 *1 -1.1,1.86 pfet
X$24 \$27 vss vddr vddr pfet_03v3 L=2U W=0.24U AS=0.308P AD=0.176P PS=2.28U
+ PD=1.24U
* device instance $25 r0 *1 0.84,1.86 pfet
X$25 a|y a|y$10 \$27 vddr pfet_03v3 L=0.28U W=0.44U AS=0.176P AD=0.176P
+ PS=1.24U PD=1.24U
* device instance $26 r0 *1 1.92,1.86 pfet
X$26 \$27 en a|y vddr pfet_03v3 L=0.28U W=0.44U AS=0.176P AD=0.352P PS=1.24U
+ PD=2.48U
* device instance $27 r0 *1 11.68,1.86 pfet
X$27 vddr vss \$28 vddr pfet_03v3 L=2U W=0.24U AS=0.088P AD=0.308P PS=0.84U
+ PD=2.28U
* device instance $28 r0 *1 10.14,1.86 pfet
X$28 \$28 a|y a|y$1 vddr pfet_03v3 L=0.28U W=0.44U AS=0.308P AD=0.088P PS=2.28U
+ PD=0.84U
* device instance $29 r0 *1 19.75,1.86 pfet
X$29 vddr vss \$29 vddr pfet_03v3 L=2U W=0.24U AS=0.088P AD=0.308P PS=0.84U
+ PD=2.28U
* device instance $30 r0 *1 18.21,1.86 pfet
X$30 \$29 a|y$1 a|y$2 vddr pfet_03v3 L=0.28U W=0.44U AS=0.308P AD=0.088P
+ PS=2.28U PD=0.84U
* device instance $31 r0 *1 27.82,1.86 pfet
X$31 vddr vss \$30 vddr pfet_03v3 L=2U W=0.24U AS=0.088P AD=0.308P PS=0.84U
+ PD=2.28U
* device instance $32 r0 *1 26.28,1.86 pfet
X$32 \$30 a|y$2 a|y$3 vddr pfet_03v3 L=0.28U W=0.44U AS=0.308P AD=0.088P
+ PS=2.28U PD=0.84U
* device instance $33 r0 *1 35.89,1.86 pfet
X$33 vddr vss \$31 vddr pfet_03v3 L=2U W=0.24U AS=0.088P AD=0.308P PS=0.84U
+ PD=2.28U
* device instance $34 r0 *1 34.35,1.86 pfet
X$34 \$31 a|y$3 a|y$4 vddr pfet_03v3 L=0.28U W=0.44U AS=0.308P AD=0.088P
+ PS=2.28U PD=0.84U
* device instance $35 r0 *1 43.96,1.86 pfet
X$35 vddr vss \$32 vddr pfet_03v3 L=2U W=0.24U AS=0.088P AD=0.308P PS=0.84U
+ PD=2.28U
* device instance $36 r0 *1 42.42,1.86 pfet
X$36 \$32 a|y$4 a|y$5 vddr pfet_03v3 L=0.28U W=0.44U AS=0.308P AD=0.088P
+ PS=2.28U PD=0.84U
* device instance $37 r0 *1 52.03,1.86 pfet
X$37 vddr vss \$33 vddr pfet_03v3 L=2U W=0.24U AS=0.088P AD=0.308P PS=0.84U
+ PD=2.28U
* device instance $38 r0 *1 50.49,1.86 pfet
X$38 \$33 a|y$5 a|y$6 vddr pfet_03v3 L=0.28U W=0.44U AS=0.308P AD=0.088P
+ PS=2.28U PD=0.84U
* device instance $39 r0 *1 60.1,1.86 pfet
X$39 vddr vss \$34 vddr pfet_03v3 L=2U W=0.24U AS=0.088P AD=0.308P PS=0.84U
+ PD=2.28U
* device instance $40 r0 *1 58.56,1.86 pfet
X$40 \$34 a|y$6 a|y$7 vddr pfet_03v3 L=0.28U W=0.44U AS=0.308P AD=0.088P
+ PS=2.28U PD=0.84U
* device instance $41 r0 *1 68.17,1.86 pfet
X$41 vddr vss \$35 vddr pfet_03v3 L=2U W=0.24U AS=0.088P AD=0.308P PS=0.84U
+ PD=2.28U
* device instance $42 r0 *1 66.63,1.86 pfet
X$42 \$35 a|y$7 a|y$8 vddr pfet_03v3 L=0.28U W=0.44U AS=0.308P AD=0.088P
+ PS=2.28U PD=0.84U
* device instance $43 r0 *1 76.24,1.86 pfet
X$43 vddr vss \$36 vddr pfet_03v3 L=2U W=0.24U AS=0.088P AD=0.308P PS=0.84U
+ PD=2.28U
* device instance $44 r0 *1 74.7,1.86 pfet
X$44 \$36 a|y$8 a|y$9 vddr pfet_03v3 L=0.28U W=0.44U AS=0.308P AD=0.088P
+ PS=2.28U PD=0.84U
* device instance $45 r0 *1 84.31,1.86 pfet
X$45 vddr vss \$37 vddr pfet_03v3 L=2U W=0.24U AS=0.088P AD=0.308P PS=0.84U
+ PD=2.28U
* device instance $46 r0 *1 82.77,1.86 pfet
X$46 \$37 a|y$9 a|y$10 vddr pfet_03v3 L=0.28U W=0.44U AS=0.308P AD=0.088P
+ PS=2.28U PD=0.84U
.ENDS ro_ring11_ring2
