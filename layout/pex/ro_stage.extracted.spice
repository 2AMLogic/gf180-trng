* extracted by klt extract --deck gf180mcu
* parasitic model (--parasitics):
* - capacitance: net-to-ground for every net's own (non-coupled) area/perimeter, plus net-to-net for the vertical-overlap coupling `coupling` describes below -- a coupled net pair gets a direct capacitor between their two hub nodes, not just capacitors to the deck's ground/substrate net
* - coupling: vertical overlap (crossover) unconditionally -- where one net's conductor on an adjacent metal level sits directly over another *distinct* net's conductor, that overlap area is charged between the two nets instead of to ground (issue #760) -- plus lateral (same-layer, sidewall) coupling, but only for a net pair naming one of the caller's declared `--critical-net` nets (issue #976): facing-edge length within that layer's own minimum-spacing lookback is charged between the two nets, *additively* (not deducted from either net's substrate fringe term, unlike the vertical case -- a known simplification). Any same-layer pair with neither side named `--critical-net`, and fringe shielding in general, are still not modelled
* - resistance: single lumped series resistance per net, distributed as a star across that net's device terminals (issue #592) -- not a per-segment, distributed RC ladder, *unless* `--distributed-rc` names this net via `--critical-net` (issue #977, Epic #709 Phase 2b): then the net's terminals are ordered along their approximate physical spread and its total R/C is broken into a chain of per-segment resistors (segment length proportional to inter-terminal distance) with a ground capacitor at each terminal node (proportional to its adjacent segment length/2), instead of one star hub -- still an approximation (terminal position is a device-placement proxy, not true per-segment routing geometry), but a strictly finer-grained one than the single-hub star
* - frequency: quasi-static -- one frequency-independent R and C per net; no skin effect, no distributed transmission-line behavior
.GLOBAL vsubs

* cell ro_stage
* pin a
* pin vddr
* pin vss
* pin vsubs
* pin y
.SUBCKT ro_stage a vddr vss vsubs y
* device instance $1 r0 *1 0.84,0.22 nfet
X$1 \$5 a__t0 y__t0 vsubs nfet_03v3 L=0.28U W=0.22U AS=0.308P AD=0.044P
+ PS=2.28U PD=0.62U
* device instance $2 r0 *1 2.38,0.22 nfet
X$2 \$5 vddr__t0 vss__t0 vsubs nfet_03v3 L=2U W=0.22U AS=0.308P AD=0.044P
+ PS=2.28U PD=0.62U
* device instance $3 r0 *1 2.38,1.86 pfet
X$3 vddr__t1 vss__t1 \$6 \$7 pfet_03v3 L=2U W=0.22U AS=0.088P AD=0.308P
+ PS=0.84U PD=2.28U
* device instance $4 r0 *1 0.84,1.86 pfet
X$4 \$6 a__t1 y__t1 \$7 pfet_03v3 L=0.28U W=0.44U AS=0.308P AD=0.088P PS=2.28U
+ PD=0.84U
* device instance a_t0 r0 *1 0,0
Ra_t0 a__t0 a 44.05965
* device instance a_t1 r0 *1 0,0
Ra_t1 a__t1 a 44.05965
* device instance a r0 *1 0,0
Ca a vsubs 5.85014e-16
* device instance vddr_t0 r0 *1 0,0
Rvddr_t0 vddr__t0 vddr 37.86835
* device instance vddr_t1 r0 *1 0,0
Rvddr_t1 vddr__t1 vddr 37.86835
* device instance vddr r0 *1 0,0
Cvddr vddr vsubs 1.011929e-15
* device instance vss_t0 r0 *1 0,0
Rvss_t0 vss__t0 vss 50.58125
* device instance vss_t1 r0 *1 0,0
Rvss_t1 vss__t1 vss 50.58125
* device instance vss r0 *1 0,0
Cvss vss vsubs 9.99581e-16
* device instance y_t0 r0 *1 0,0
Ry_t0 y__t0 y 0.3981
* device instance y_t1 r0 *1 0,0
Ry_t1 y__t1 y 0.3981
* device instance y r0 *1 0,0
Cy y vsubs 2.29141e-16
* device instance vsubs_dctie r0 *1 0,0
Rvsubs_dctie vsubs 0 1e+12
.ENDS ro_stage
