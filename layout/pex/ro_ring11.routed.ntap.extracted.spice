* GENERATED by layout/pex/build.py -- do not edit by hand.
* NOISE-TAPPED variant of ro_ring11 (ro_ring11.routed.extracted.spice): the same
* cards and the same parasitics, with each of this ring's 11 inter-stage
* nets split into a driver-side hub (its existing `.SUBCKT` header token)
* and a receiver-side hub `rx<j>` carrying only that net's
* gate-connected terminals. Both are ports, so a testbench can place a
* series `trnoise` source between them; tie each pair together and this
* subcircuit is ELECTRICALLY IDENTICAL to ro_ring11 -- a 0 V source is a short,
* so every star resistance and the net's grounded capacitance are untouched.
* That equivalence is held to BYTE equality by
* layout/tests/test_pex_noise_tap.py, which un-taps this file and compares
* it against the committed untapped one.
* Exists because ngspice cannot insert a series source inside a subcircuit
* and, at routing level, the inter-stage wire IS inside one. See
* layout/pex/build.py's module docstring, "Per-stage noise injection".
* Regenerate with: python3 layout/pex/build.py
* extracted by klt extract --deck gf180mcu
* parasitic model (--parasitics):
* - capacitance: net-to-ground for every net's own (non-coupled) area/perimeter, plus net-to-net for the vertical-overlap coupling `coupling` describes below -- a coupled net pair gets a direct capacitor between their two hub nodes, not just capacitors to the deck's ground/substrate net
* - coupling: vertical overlap (crossover) unconditionally -- where one net's conductor on an adjacent metal level sits directly over another *distinct* net's conductor, that overlap area is charged between the two nets instead of to ground (issue #760) -- plus lateral (same-layer, sidewall) coupling, but only for a net pair naming one of the caller's declared `--critical-net` nets (issue #976): facing-edge length within that layer's own minimum-spacing lookback is charged between the two nets, *additively* (not deducted from either net's substrate fringe term, unlike the vertical case -- a known simplification). Any same-layer pair with neither side named `--critical-net`, and fringe shielding in general, are still not modelled
* - resistance: single lumped series resistance per net, distributed as a star across that net's device terminals (issue #592) -- not a per-segment, distributed RC ladder, *unless* `--distributed-rc` names this net via `--critical-net` (issue #977, Epic #709 Phase 2b): then the net's terminals are ordered along their approximate physical spread and its total R/C is broken into a chain of per-segment resistors (segment length proportional to inter-terminal distance) with a ground capacitor at each terminal node (proportional to its adjacent segment length/2), instead of one star hub -- still an approximation (terminal position is a device-placement proxy, not true per-segment routing geometry), but a strictly finer-grained one than the single-hub star
* - frequency: quasi-static -- one frequency-independent R and C per net; no skin effect, no distributed transmission-line behavior
.GLOBAL vsubs

* cell ro_ring11_ntap
* pin a,y
* pin a,y
* pin a,y
* pin a,y
* pin a,y
* pin a,y
* pin a,y
* pin a,y
* pin a,y
* pin a,y
* pin a,y
* pin en
* pin vddr
* pin vss
* pin vsubs
.SUBCKT ro_ring11_ntap a|y a|y$1 a|y$2 a|y$3 a|y$4 a|y$5 a|y$6 a|y$7 a|y$8 a|y$9 a|y$10 en vddr vss vsubs rx0 rx1 rx2 rx3 rx4 rx5 rx6 rx7 rx8 rx9 rx10
* device instance $1 r0 *1 8.9,0.22 nfet
X$1 \$15 a\x7cy__t0 a\x7cy__t02 vsubs nfet_03v3 L=0.28U W=0.22U AS=0.308P
+ AD=0.044P PS=2.28U PD=0.62U
* device instance $2 r0 *1 10.44,0.22 nfet
X$2 \$15 vddr__t0 vss__t0 vsubs nfet_03v3 L=2U W=0.22U AS=0.308P AD=0.044P
+ PS=2.28U PD=0.62U
* device instance $3 r0 *1 15.73,0.22 nfet
X$3 \$17 a\x7cy__t32 a\x7cy__t13 vsubs nfet_03v3 L=0.28U W=0.22U AS=0.308P
+ AD=0.044P PS=2.28U PD=0.62U
* device instance $4 r0 *1 17.27,0.22 nfet
X$4 \$17 vddr__t21 vss__t21 vsubs nfet_03v3 L=2U W=0.22U AS=0.308P AD=0.044P
+ PS=2.28U PD=0.62U
* device instance $5 r0 *1 22.56,0.22 nfet
X$5 \$18 a\x7cy__t33 a\x7cy__t14 vsubs nfet_03v3 L=0.28U W=0.22U AS=0.308P
+ AD=0.044P PS=2.28U PD=0.62U
* device instance $6 r0 *1 24.1,0.22 nfet
X$6 \$18 vddr__t20 vss__t20 vsubs nfet_03v3 L=2U W=0.22U AS=0.308P AD=0.044P
+ PS=2.28U PD=0.62U
* device instance $7 r0 *1 29.39,0.22 nfet
X$7 \$20 a\x7cy__t34 a\x7cy__t15 vsubs nfet_03v3 L=0.28U W=0.22U AS=0.308P
+ AD=0.044P PS=2.28U PD=0.62U
* device instance $8 r0 *1 30.93,0.22 nfet
X$8 \$20 vddr__t19 vss__t19 vsubs nfet_03v3 L=2U W=0.22U AS=0.308P AD=0.044P
+ PS=2.28U PD=0.62U
* device instance $9 r0 *1 36.22,0.22 nfet
X$9 \$21 a\x7cy__t35 a\x7cy__t16 vsubs nfet_03v3 L=0.28U W=0.22U AS=0.308P
+ AD=0.044P PS=2.28U PD=0.62U
* device instance $10 r0 *1 37.76,0.22 nfet
X$10 \$21 vddr__t18 vss__t18 vsubs nfet_03v3 L=2U W=0.22U AS=0.308P AD=0.044P
+ PS=2.28U PD=0.62U
* device instance $11 r0 *1 43.05,0.22 nfet
X$11 \$22 a\x7cy__t36 a\x7cy__t17 vsubs nfet_03v3 L=0.28U W=0.22U AS=0.308P
+ AD=0.044P PS=2.28U PD=0.62U
* device instance $12 r0 *1 44.59,0.22 nfet
X$12 \$22 vddr__t17 vss__t17 vsubs nfet_03v3 L=2U W=0.22U AS=0.308P AD=0.044P
+ PS=2.28U PD=0.62U
* device instance $13 r0 *1 49.88,0.22 nfet
X$13 \$24 a\x7cy__t37 a\x7cy__t18 vsubs nfet_03v3 L=0.28U W=0.22U AS=0.308P
+ AD=0.044P PS=2.28U PD=0.62U
* device instance $14 r0 *1 51.42,0.22 nfet
X$14 \$24 vddr__t16 vss__t16 vsubs nfet_03v3 L=2U W=0.22U AS=0.308P AD=0.044P
+ PS=2.28U PD=0.62U
* device instance $15 r0 *1 56.71,0.22 nfet
X$15 \$23 a\x7cy__t38 a\x7cy__t19 vsubs nfet_03v3 L=0.28U W=0.22U AS=0.308P
+ AD=0.044P PS=2.28U PD=0.62U
* device instance $16 r0 *1 58.25,0.22 nfet
X$16 \$23 vddr__t15 vss__t15 vsubs nfet_03v3 L=2U W=0.22U AS=0.308P AD=0.044P
+ PS=2.28U PD=0.62U
* device instance $17 r0 *1 63.54,0.22 nfet
X$17 \$19 a\x7cy__t39 a\x7cy__t110 vsubs nfet_03v3 L=0.28U W=0.22U AS=0.308P
+ AD=0.044P PS=2.28U PD=0.62U
* device instance $18 r0 *1 65.08,0.22 nfet
X$18 \$19 vddr__t14 vss__t14 vsubs nfet_03v3 L=2U W=0.22U AS=0.308P AD=0.044P
+ PS=2.28U PD=0.62U
* device instance $19 r0 *1 70.37,0.22 nfet
X$19 \$16 a\x7cy__t310 a\x7cy__t311 vsubs nfet_03v3 L=0.28U W=0.22U AS=0.308P
+ AD=0.044P PS=2.28U PD=0.62U
* device instance $20 r0 *1 71.91,0.22 nfet
X$20 \$16 vddr__t13 vss__t13 vsubs nfet_03v3 L=2U W=0.22U AS=0.308P AD=0.044P
+ PS=2.28U PD=0.62U
* device instance $21 r0 *1 3.86,0.22 nfet
X$21 vss__t1 vddr__t1 \$14 vsubs nfet_03v3 L=2U W=0.22U AS=0.176P AD=0.308P
+ PS=1.24U PD=2.28U
* device instance $22 r0 *1 0.84,0.22 nfet
X$22 \$13 a\x7cy__t011 a\x7cy__t1 vsubs nfet_03v3 L=0.28U W=0.44U AS=0.308P
+ AD=0.176P PS=2.28U PD=1.24U
* device instance $23 r0 *1 1.92,0.22 nfet
X$23 \$14 en__t0 \$13 vsubs nfet_03v3 L=0.28U W=0.44U AS=0.176P AD=0.176P
+ PS=1.24U PD=1.24U
* device instance $24 r0 *1 -1.1,1.86 pfet
X$24 \$27__t1 vss__t2 vddr__t2 \$28 pfet_03v3 L=2U W=0.22U AS=0.308P AD=0.176P
+ PS=2.28U PD=1.24U
* device instance $25 r0 *1 0.84,1.86 pfet
X$25 a\x7cy__t3 a\x7cy__t111 \$27__t2 \$28 pfet_03v3 L=0.28U W=0.44U AS=0.176P
+ AD=0.176P PS=1.24U PD=1.24U
* device instance $26 r0 *1 1.92,1.86 pfet
X$26 \$27__t0 en__t1 a\x7cy__t4 \$28 pfet_03v3 L=0.28U W=0.44U AS=0.176P
+ AD=0.352P PS=1.24U PD=2.48U
* device instance $27 r0 *1 10.44,1.86 pfet
X$27 vddr__t3 vss__t3 \$29 \$30 pfet_03v3 L=2U W=0.22U AS=0.088P AD=0.308P
+ PS=0.84U PD=2.28U
* device instance $28 r0 *1 8.9,1.86 pfet
X$28 \$29 a\x7cy__t2 a\x7cy__t12 \$30 pfet_03v3 L=0.28U W=0.44U AS=0.308P
+ AD=0.088P PS=2.28U PD=0.84U
* device instance $29 r0 *1 17.27,1.86 pfet
X$29 vddr__t12 vss__t12 \$31 \$32 pfet_03v3 L=2U W=0.22U AS=0.088P AD=0.308P
+ PS=0.84U PD=2.28U
* device instance $30 r0 *1 15.73,1.86 pfet
X$30 \$31 a\x7cy__t22 a\x7cy__t03 \$32 pfet_03v3 L=0.28U W=0.44U AS=0.308P
+ AD=0.088P PS=2.28U PD=0.84U
* device instance $31 r0 *1 24.1,1.86 pfet
X$31 vddr__t11 vss__t11 \$33 \$34 pfet_03v3 L=2U W=0.22U AS=0.088P AD=0.308P
+ PS=0.84U PD=2.28U
* device instance $32 r0 *1 22.56,1.86 pfet
X$32 \$33 a\x7cy__t23 a\x7cy__t04 \$34 pfet_03v3 L=0.28U W=0.44U AS=0.308P
+ AD=0.088P PS=2.28U PD=0.84U
* device instance $33 r0 *1 30.93,1.86 pfet
X$33 vddr__t10 vss__t10 \$35 \$36 pfet_03v3 L=2U W=0.22U AS=0.088P AD=0.308P
+ PS=0.84U PD=2.28U
* device instance $34 r0 *1 29.39,1.86 pfet
X$34 \$35 a\x7cy__t24 a\x7cy__t05 \$36 pfet_03v3 L=0.28U W=0.44U AS=0.308P
+ AD=0.088P PS=2.28U PD=0.84U
* device instance $35 r0 *1 37.76,1.86 pfet
X$35 vddr__t9 vss__t9 \$37 \$38 pfet_03v3 L=2U W=0.22U AS=0.088P AD=0.308P
+ PS=0.84U PD=2.28U
* device instance $36 r0 *1 36.22,1.86 pfet
X$36 \$37 a\x7cy__t25 a\x7cy__t06 \$38 pfet_03v3 L=0.28U W=0.44U AS=0.308P
+ AD=0.088P PS=2.28U PD=0.84U
* device instance $37 r0 *1 44.59,1.86 pfet
X$37 vddr__t8 vss__t8 \$39 \$40 pfet_03v3 L=2U W=0.22U AS=0.088P AD=0.308P
+ PS=0.84U PD=2.28U
* device instance $38 r0 *1 43.05,1.86 pfet
X$38 \$39 a\x7cy__t26 a\x7cy__t07 \$40 pfet_03v3 L=0.28U W=0.44U AS=0.308P
+ AD=0.088P PS=2.28U PD=0.84U
* device instance $39 r0 *1 51.42,1.86 pfet
X$39 vddr__t7 vss__t7 \$41 \$42 pfet_03v3 L=2U W=0.22U AS=0.088P AD=0.308P
+ PS=0.84U PD=2.28U
* device instance $40 r0 *1 49.88,1.86 pfet
X$40 \$41 a\x7cy__t27 a\x7cy__t08 \$42 pfet_03v3 L=0.28U W=0.44U AS=0.308P
+ AD=0.088P PS=2.28U PD=0.84U
* device instance $41 r0 *1 58.25,1.86 pfet
X$41 vddr__t6 vss__t6 \$43 \$44 pfet_03v3 L=2U W=0.22U AS=0.088P AD=0.308P
+ PS=0.84U PD=2.28U
* device instance $42 r0 *1 56.71,1.86 pfet
X$42 \$43 a\x7cy__t28 a\x7cy__t09 \$44 pfet_03v3 L=0.28U W=0.44U AS=0.308P
+ AD=0.088P PS=2.28U PD=0.84U
* device instance $43 r0 *1 65.08,1.86 pfet
X$43 vddr__t5 vss__t5 \$45 \$46 pfet_03v3 L=2U W=0.22U AS=0.088P AD=0.308P
+ PS=0.84U PD=2.28U
* device instance $44 r0 *1 63.54,1.86 pfet
X$44 \$45 a\x7cy__t29 a\x7cy__t010 \$46 pfet_03v3 L=0.28U W=0.44U AS=0.308P
+ AD=0.088P PS=2.28U PD=0.84U
* device instance $45 r0 *1 71.91,1.86 pfet
X$45 vddr__t4 vss__t4 \$47 \$48 pfet_03v3 L=2U W=0.22U AS=0.088P AD=0.308P
+ PS=0.84U PD=2.28U
* device instance $46 r0 *1 70.37,1.86 pfet
X$46 \$47 a\x7cy__t210 a\x7cy__t211 \$48 pfet_03v3 L=0.28U W=0.44U AS=0.308P
+ AD=0.088P PS=2.28U PD=0.84U
* device instance _27_t0 r0 *1 0,0
R_27_t0 \$27__t0 \$27 0.450297379032
* device instance _27_t1 r0 *1 0,0
R_27_t1 \$27__t1 \$27 0.54475
* device instance _27_t2 r0 *1 0,0
R_27_t2 \$27__t2 \$27 0.0944526209677
* device instance _27 r0 *1 0,0
C_27 \$27 vsubs 3.21733e-16
* device instance a_y_t0 r0 *1 0,0
Ra_y_t0 a\x7cy__t0 rx0 23.1258565818
* device instance a_y_t1 r0 *1 0,0
Ra_y_t1 a\x7cy__t1 a|y 17.5169569217
* device instance a_y_t2 r0 *1 0,0
Ra_y_t2 a\x7cy__t2 rx0 22.8453934594
* device instance a_y_t3 r0 *1 0,0
Ra_y_t3 a\x7cy__t3 a|y 17.1449858405
* device instance a_y_t4 r0 *1 0,0
Ra_y_t4 a\x7cy__t4 a|y 11.9921071967
* device instance a_y r0 *1 0,0
Ca_y a|y vsubs 1.878139e-15
* device instance a_y_dup1_t0 r0 *1 0,0
Ra_y_dup1_t0 a\x7cy__t02 a|y$1 22.9637
* device instance a_y_dup1_t1 r0 *1 0,0
Ra_y_dup1_t1 a\x7cy__t12 a|y$1 22.9637
* device instance a_y_dup1_t2 r0 *1 0,0
Ra_y_dup1_t2 a\x7cy__t22 rx1 22.9637
* device instance a_y_dup1_t3 r0 *1 0,0
Ra_y_dup1_t3 a\x7cy__t32 rx1 22.9637
* device instance a_y_dup1 r0 *1 0,0
Ca_y_dup1 a|y$1 vsubs 1.647434e-15
* device instance a_y_dup2_t0 r0 *1 0,0
Ra_y_dup2_t0 a\x7cy__t03 a|y$2 22.9637
* device instance a_y_dup2_t1 r0 *1 0,0
Ra_y_dup2_t1 a\x7cy__t13 a|y$2 22.9637
* device instance a_y_dup2_t2 r0 *1 0,0
Ra_y_dup2_t2 a\x7cy__t23 rx2 22.9637
* device instance a_y_dup2_t3 r0 *1 0,0
Ra_y_dup2_t3 a\x7cy__t33 rx2 22.9637
* device instance a_y_dup2 r0 *1 0,0
Ca_y_dup2 a|y$2 vsubs 1.647434e-15
* device instance a_y_dup3_t0 r0 *1 0,0
Ra_y_dup3_t0 a\x7cy__t04 a|y$3 22.9637
* device instance a_y_dup3_t1 r0 *1 0,0
Ra_y_dup3_t1 a\x7cy__t14 a|y$3 22.9637
* device instance a_y_dup3_t2 r0 *1 0,0
Ra_y_dup3_t2 a\x7cy__t24 rx3 22.9637
* device instance a_y_dup3_t3 r0 *1 0,0
Ra_y_dup3_t3 a\x7cy__t34 rx3 22.9637
* device instance a_y_dup3 r0 *1 0,0
Ca_y_dup3 a|y$3 vsubs 1.647434e-15
* device instance a_y_dup4_t0 r0 *1 0,0
Ra_y_dup4_t0 a\x7cy__t05 a|y$4 22.9637
* device instance a_y_dup4_t1 r0 *1 0,0
Ra_y_dup4_t1 a\x7cy__t15 a|y$4 22.9637
* device instance a_y_dup4_t2 r0 *1 0,0
Ra_y_dup4_t2 a\x7cy__t25 rx4 22.9637
* device instance a_y_dup4_t3 r0 *1 0,0
Ra_y_dup4_t3 a\x7cy__t35 rx4 22.9637
* device instance a_y_dup4 r0 *1 0,0
Ca_y_dup4 a|y$4 vsubs 1.647434e-15
* device instance a_y_dup5_t0 r0 *1 0,0
Ra_y_dup5_t0 a\x7cy__t06 a|y$5 22.9637
* device instance a_y_dup5_t1 r0 *1 0,0
Ra_y_dup5_t1 a\x7cy__t16 a|y$5 22.9637
* device instance a_y_dup5_t2 r0 *1 0,0
Ra_y_dup5_t2 a\x7cy__t26 rx5 22.9637
* device instance a_y_dup5_t3 r0 *1 0,0
Ra_y_dup5_t3 a\x7cy__t36 rx5 22.9637
* device instance a_y_dup5 r0 *1 0,0
Ca_y_dup5 a|y$5 vsubs 1.647434e-15
* device instance a_y_dup6_t0 r0 *1 0,0
Ra_y_dup6_t0 a\x7cy__t07 a|y$6 22.9637
* device instance a_y_dup6_t1 r0 *1 0,0
Ra_y_dup6_t1 a\x7cy__t17 a|y$6 22.9637
* device instance a_y_dup6_t2 r0 *1 0,0
Ra_y_dup6_t2 a\x7cy__t27 rx6 22.9637
* device instance a_y_dup6_t3 r0 *1 0,0
Ra_y_dup6_t3 a\x7cy__t37 rx6 22.9637
* device instance a_y_dup6 r0 *1 0,0
Ca_y_dup6 a|y$6 vsubs 1.647434e-15
* device instance a_y_dup7_t0 r0 *1 0,0
Ra_y_dup7_t0 a\x7cy__t08 a|y$7 22.9637
* device instance a_y_dup7_t1 r0 *1 0,0
Ra_y_dup7_t1 a\x7cy__t18 a|y$7 22.9637
* device instance a_y_dup7_t2 r0 *1 0,0
Ra_y_dup7_t2 a\x7cy__t28 rx7 22.9637
* device instance a_y_dup7_t3 r0 *1 0,0
Ra_y_dup7_t3 a\x7cy__t38 rx7 22.9637
* device instance a_y_dup7 r0 *1 0,0
Ca_y_dup7 a|y$7 vsubs 1.647434e-15
* device instance a_y_dup8_t0 r0 *1 0,0
Ra_y_dup8_t0 a\x7cy__t09 a|y$8 22.9637
* device instance a_y_dup8_t1 r0 *1 0,0
Ra_y_dup8_t1 a\x7cy__t19 a|y$8 22.9637
* device instance a_y_dup8_t2 r0 *1 0,0
Ra_y_dup8_t2 a\x7cy__t29 rx8 22.9637
* device instance a_y_dup8_t3 r0 *1 0,0
Ra_y_dup8_t3 a\x7cy__t39 rx8 22.9637
* device instance a_y_dup8 r0 *1 0,0
Ca_y_dup8 a|y$8 vsubs 1.647434e-15
* device instance a_y_dup9_t0 r0 *1 0,0
Ra_y_dup9_t0 a\x7cy__t010 a|y$9 22.9637
* device instance a_y_dup9_t1 r0 *1 0,0
Ra_y_dup9_t1 a\x7cy__t110 a|y$9 22.9637
* device instance a_y_dup9_t2 r0 *1 0,0
Ra_y_dup9_t2 a\x7cy__t210 rx9 22.9637
* device instance a_y_dup9_t3 r0 *1 0,0
Ra_y_dup9_t3 a\x7cy__t310 rx9 22.9637
* device instance a_y_dup9 r0 *1 0,0
Ca_y_dup9 a|y$9 vsubs 1.647434e-15
* device instance a_y_dup10_t0 r0 *1 0,0
Ra_y_dup10_t0 a\x7cy__t011 rx10 26.458525
* device instance a_y_dup10_t1 r0 *1 0,0
Ra_y_dup10_t1 a\x7cy__t111 rx10 26.458525
* device instance a_y_dup10_t2 r0 *1 0,0
Ra_y_dup10_t2 a\x7cy__t211 a|y$10 26.458525
* device instance a_y_dup10_t3 r0 *1 0,0
Ra_y_dup10_t3 a\x7cy__t311 a|y$10 26.458525
* device instance a_y_dup10 r0 *1 0,0
Ca_y_dup10 a|y$10 vsubs 7.889961e-15
* device instance en_t0 r0 *1 0,0
Ren_t0 en__t0 en 40.2386
* device instance en_t1 r0 *1 0,0
Ren_t1 en__t1 en 40.2386
* device instance en r0 *1 0,0
Cen en vsubs 4.38142e-16
* device instance vddr_t0 r0 *1 0,0
Rvddr_t0 vddr__t0 vddr 66.1083908517
* device instance vddr_t1 r0 *1 0,0
Rvddr_t1 vddr__t1 vddr 82.1363517954
* device instance vddr_t2 r0 *1 0,0
Rvddr_t2 vddr__t2 vddr 94.2195452065
* device instance vddr_t3 r0 *1 0,0
Rvddr_t3 vddr__t3 vddr 66.1083908517
* device instance vddr_t4 r0 *1 0,0
Rvddr_t4 vddr__t4 vddr 83.733071161
* device instance vddr_t5 r0 *1 0,0
Rvddr_t5 vddr__t5 vddr 67.0959400396
* device instance vddr_t6 r0 *1 0,0
Rvddr_t6 vddr__t6 vddr 50.4627099034
* device instance vddr_t7 r0 *1 0,0
Rvddr_t7 vddr__t7 vddr 33.8391336924
* device instance vddr_t8 r0 *1 0,0
Rvddr_t8 vddr__t8 vddr 17.2531389771
* device instance vddr_t9 r0 *1 0,0
Rvddr_t9 vddr__t9 vddr 2.05829962223
* device instance vddr_t10 r0 *1 0,0
Rvddr_t10 vddr__t10 vddr 16.2721955299
* device instance vddr_t11 r0 *1 0,0
Rvddr_t11 vddr__t11 vddr 32.8529154665
* device instance vddr_t12 r0 *1 0,0
Rvddr_t12 vddr__t12 vddr 49.4755062551
* device instance vddr_t13 r0 *1 0,0
Rvddr_t13 vddr__t13 vddr 83.733071161
* device instance vddr_t14 r0 *1 0,0
Rvddr_t14 vddr__t14 vddr 67.0959400396
* device instance vddr_t15 r0 *1 0,0
Rvddr_t15 vddr__t15 vddr 50.4627099034
* device instance vddr_t16 r0 *1 0,0
Rvddr_t16 vddr__t16 vddr 33.8391336924
* device instance vddr_t17 r0 *1 0,0
Rvddr_t17 vddr__t17 vddr 17.2531389771
* device instance vddr_t18 r0 *1 0,0
Rvddr_t18 vddr__t18 vddr 2.05829962223
* device instance vddr_t19 r0 *1 0,0
Rvddr_t19 vddr__t19 vddr 16.2721955299
* device instance vddr_t20 r0 *1 0,0
Rvddr_t20 vddr__t20 vddr 32.8529154665
* device instance vddr_t21 r0 *1 0,0
Rvddr_t21 vddr__t21 vddr 49.4755062551
* device instance vddr r0 *1 0,0
Cvddr vddr vsubs 1.7311274e-14
* device instance vss_t0 r0 *1 0,0
Rvss_t0 vss__t0 vss 87.3321045856
* device instance vss_t1 r0 *1 0,0
Rvss_t1 vss__t1 vss 108.505749011
* device instance vss_t2 r0 *1 0,0
Rvss_t2 vss__t2 vss 124.46818127
* device instance vss_t3 r0 *1 0,0
Rvss_t3 vss__t3 vss 87.3321045856
* device instance vss_t4 r0 *1 0,0
Rvss_t4 vss__t4 vss 110.615085826
* device instance vss_t5 r0 *1 0,0
Rvss_t5 vss__t5 vss 88.6367006867
* device instance vss_t6 r0 *1 0,0
Rvss_t6 vss__t6 vss 66.6634689209
* device instance vss_t7 r0 *1 0,0
Rvss_t7 vss__t7 vss 44.7029904167
* device instance vss_t8 r0 *1 0,0
Rvss_t8 vss__t8 vss 22.7921587285
* device instance vss_t9 r0 *1 0,0
Rvss_t9 vss__t9 vss 2.71910472425
* device instance vss_t10 r0 *1 0,0
Rvss_t10 vss__t10 vss 21.4962891026
* device instance vss_t11 r0 *1 0,0
Rvss_t11 vss__t11 vss 43.4001525752
* device instance vss_t12 r0 *1 0,0
Rvss_t12 vss__t12 vss 65.3593292928
* device instance vss_t13 r0 *1 0,0
Rvss_t13 vss__t13 vss 110.615085826
* device instance vss_t14 r0 *1 0,0
Rvss_t14 vss__t14 vss 88.6367006867
* device instance vss_t15 r0 *1 0,0
Rvss_t15 vss__t15 vss 66.6634689209
* device instance vss_t16 r0 *1 0,0
Rvss_t16 vss__t16 vss 44.7029904167
* device instance vss_t17 r0 *1 0,0
Rvss_t17 vss__t17 vss 22.7921587285
* device instance vss_t18 r0 *1 0,0
Rvss_t18 vss__t18 vss 2.71910472425
* device instance vss_t19 r0 *1 0,0
Rvss_t19 vss__t19 vss 21.4962891026
* device instance vss_t20 r0 *1 0,0
Rvss_t20 vss__t20 vss 43.4001525752
* device instance vss_t21 r0 *1 0,0
Rvss_t21 vss__t21 vss 65.3593292928
* device instance vss r0 *1 0,0
Cvss vss vsubs 1.6989221e-14
* device instance cc__27_vddr r0 *1 0,0
Ccc__27_vddr \$27 vddr 9.208e-18
* device instance cc_a_y_vddr r0 *1 0,0
Ccc_a_y_vddr a|y$10 vddr 1.62295e-16
* device instance cc_a_y_vss r0 *1 0,0
Ccc_a_y_vss a|y$10 vss 1.11762e-16
* device instance cc_vddr_vss r0 *1 0,0
Ccc_vddr_vss vddr vss 1.4048e-17
* device instance vsubs_dctie r0 *1 0,0
Rvsubs_dctie vsubs 0 1e+12
.ENDS ro_ring11_ntap
