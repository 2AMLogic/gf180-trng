* GENERATED by layout/pex/build.py -- do not edit by hand.
* Post-layout, device-level-parasitic-annotated drop-in replacement for
* design/sampler_core.spice, composed from `klt extract --parasitics --pdk gf180mcuD` runs
* over this design's individually drawn, DRC-clean, LVS-matching leaf
* cells (layout/cells/), using EXACTLY the instance-level topology
* design/sampler_core.spice itself declares -- see this file's own module docstring
* (layout/pex/build.py) for what this captures and what it does not.
* Regenerate with: python3 layout/pex/build.py
.include "ro_array_core.extracted.spice"
.include "sampler_dff.extracted.spice"

.subckt sampler_core_extracted en1 en2 vddr1 vddr2 vdd vss clk rst_n raw_bit raw_valid ring_bit1 ring_bit2 vsubs
xdut en1 en2 vddr1 vddr2 vdd vss xo ro1 ro2 vsubs ro_array_core_extracted
xsb clk xo raw_bit rst_n vdd vss vsubs sampler_dff
xsv clk vdd raw_valid rst_n vdd vss vsubs sampler_dff
xsr1 clk ro1 ring_bit1 rst_n vdd vss vsubs sampler_dff
xsr2 clk ro2 ring_bit2 rst_n vdd vss vsubs sampler_dff
.ends
