* GENERATED by layout/pex/build.py -- do not edit by hand.
* The DUT bundle sim/tb/sampler-array-digitize-extracted-routed/ needs, and
* nothing else: the two NOISE-TAPPED routing-level rings behind clean
* wrappers, plus the leaf-level `xor2` and `sampler_dff` extractions.
* That deck restates ro_array_core's top-level wiring in its own fragment
* (its pre-layout ancestor already did, and its manifest says why), so what
* it needs from layout/pex/ is the cell library, not a composed core.
* PARTIAL BY CONSTRUCTION, and deliberately so: the two rings are
* routing-level, `xor2`/`sampler_dff` are leaf-level. That is exactly the
* leaf-level deck's own topology with the rings swapped, which is what makes
* the leaf-vs-routed delta attributable to the ring routing -- the only
* place that testbench's entropy comes from. Substituting
* `combiner_sampler_routed_extracted` would also have changed the TOPOLOGY
* (it carries two `ro_buf` instances and the two ring-liveness samplers that
* this deck's pre-layout ancestor does not instantiate).
* Each ring wrapper's tapped ports follow its base `en ro vddr vss vsubs`
* interface in this order -- the contract with that testbench's own
* positional instantiation line:
*   ro_ring11_routed_ntap:       n1 n1__rx n2 n2__rx n3 n3__rx n4 n4__rx n5 n5__rx n6 n6__rx n7 n7__rx n8 n8__rx n9 n9__rx n10 n10__rx ro__rx
*   ro_ring11_ring2_routed_ntap: ro__rx n1 n1__rx n2 n2__rx n3 n3__rx n4 n4__rx n5 n5__rx n6 n6__rx n7 n7__rx n8 n8__rx n9 n9__rx n10 n10__rx
* Regenerate with: python3 layout/pex/build.py
.include "ro_ring11.routed.ntap.extracted.spice"
.include "ro_ring11_ring2.routed.ntap.extracted.spice"
.include "xor2.extracted.spice"
.include "sampler_dff.extracted.spice"

.subckt ro_ring11_routed_ntap en ro vddr vss vsubs n1 n1__rx n2 n2__rx n3 n3__rx n4 n4__rx n5 n5__rx n6 n6__rx n7 n7__rx n8 n8__rx n9 n9__rx n10 n10__rx ro__rx
xcore n1 n2 n3 n4 n5 n6 n7 n8 n9 n10 ro en vddr vss vsubs n1__rx n2__rx n3__rx n4__rx n5__rx n6__rx n7__rx n8__rx n9__rx n10__rx ro__rx ro_ring11_ntap
.ends

.subckt ro_ring11_ring2_routed_ntap en ro vddr vss vsubs ro__rx n1 n1__rx n2 n2__rx n3 n3__rx n4 n4__rx n5 n5__rx n6 n6__rx n7 n7__rx n8 n8__rx n9 n9__rx n10 n10__rx
xcore ro n1 n2 n3 n4 n5 n6 n7 n8 n9 n10 en vddr vss vsubs ro__rx n1__rx n2__rx n3__rx n4__rx n5__rx n6__rx n7__rx n8__rx n9__rx n10__rx ro_ring11_ring2_ntap
.ends
