* extracted by klt extract --deck gf180mcu
* parasitic model (--parasitics):
* - capacitance: net-to-ground for every net's own (non-coupled) area/perimeter, plus net-to-net for the vertical-overlap coupling `coupling` describes below -- a coupled net pair gets a direct capacitor between their two hub nodes, not just capacitors to the deck's ground/substrate net
* - coupling: vertical overlap (crossover) unconditionally -- where one net's conductor on an adjacent metal level sits directly over another *distinct* net's conductor, that overlap area is charged between the two nets instead of to ground (issue #760) -- plus lateral (same-layer, sidewall) coupling, but only for a net pair naming one of the caller's declared `--critical-net` nets (issue #976): facing-edge length within that layer's own minimum-spacing lookback is charged between the two nets, *additively* (not deducted from either net's substrate fringe term, unlike the vertical case -- a known simplification). Any same-layer pair with neither side named `--critical-net`, and fringe shielding in general, are still not modelled
* - resistance: single lumped series resistance per net, distributed as a star across that net's device terminals (issue #592) -- not a per-segment, distributed RC ladder, *unless* `--distributed-rc` names this net via `--critical-net` (issue #977, Epic #709 Phase 2b): then the net's terminals are ordered along their approximate physical spread and its total R/C is broken into a chain of per-segment resistors (segment length proportional to inter-terminal distance) with a ground capacitor at each terminal node (proportional to its adjacent segment length/2), instead of one star hub -- still an approximation (terminal position is a device-placement proxy, not true per-segment routing geometry), but a strictly finer-grained one than the single-hub star
* - frequency: quasi-static -- one frequency-independent R and C per net; no skin effect, no distributed transmission-line behavior
.GLOBAL vsubs

* cell sampler_dff
* pin clk
* pin d
* pin q
* pin rst_n
* pin vdd
* pin vss
* pin vsubs
.SUBCKT sampler_dff clk d q rst_n vdd vss vsubs
* device instance $1 r0 *1 0.8,1 nfet
X$1 \$2__t0 clk__t3 vss__t0 vsubs nfet_03v3 L=0.28U W=0.22U AS=0.3872P
+ AD=0.3872P PS=2.64U PD=2.64U
* device instance $2 r0 *1 3.2,1 nfet
X$2 d__t1 \$2__t1 \$3__t5 vsubs nfet_03v3 L=0.28U W=0.22U AS=0.3872P AD=0.3872P
+ PS=2.64U PD=2.64U
* device instance $3 r0 *1 5.6,1 nfet
X$3 \$5__t3 \$13__t5 vss__t4 vsubs nfet_03v3 L=0.28U W=0.22U AS=0.3872P
+ AD=0.3872P PS=2.64U PD=2.64U
* device instance $4 r0 *1 8,1 nfet
X$4 \$5__t2 clk__t5 \$3__t4 vsubs nfet_03v3 L=0.28U W=0.22U AS=0.3872P
+ AD=0.3872P PS=2.64U PD=2.64U
* device instance $5 r0 *1 10.4,1 nfet
X$5 \$13__t6 clk__t4 \$6__t5 vsubs nfet_03v3 L=0.28U W=0.22U AS=0.3872P
+ AD=0.3872P PS=2.64U PD=2.64U
* device instance $6 r0 *1 12.8,1 nfet
X$6 q__t3 \$6__t3 vss__t3 vsubs nfet_03v3 L=0.28U W=0.22U AS=0.3872P AD=0.3872P
+ PS=2.64U PD=2.64U
* device instance $7 r0 *1 15.2,1 nfet
X$7 \$8__t4 \$2__t5 \$6__t4 vsubs nfet_03v3 L=0.28U W=0.22U AS=0.3872P
+ AD=0.3872P PS=2.64U PD=2.64U
* device instance $8 r0 *1 17.6,1 nfet
X$8 \$13__t0 \$3__t0 \$9__t1 vsubs nfet_03v3 L=0.28U W=0.44U AS=0.3872P
+ AD=0.3872P PS=2.64U PD=2.64U
* device instance $9 r0 *1 20,1 nfet
X$9 \$9__t0 rst_n__t1 vss__t1 vsubs nfet_03v3 L=0.28U W=0.44U AS=0.3872P
+ AD=0.3872P PS=2.64U PD=2.64U
* device instance $10 r0 *1 22.4,1 nfet
X$10 \$8__t0 q__t0 \$10__t1 vsubs nfet_03v3 L=0.28U W=0.44U AS=0.3872P
+ AD=0.3872P PS=2.64U PD=2.64U
* device instance $11 r0 *1 24.8,1 nfet
X$11 \$10__t0 rst_n__t0 vss__t2 vsubs nfet_03v3 L=0.28U W=0.44U AS=0.3872P
+ AD=0.3872P PS=2.64U PD=2.64U
* device instance $12 r0 *1 29.4,1 pfet
X$12 \$2__t2 clk__t0 vdd__t0 \$15 pfet_03v3 L=0.28U W=0.44U AS=0.3872P
+ AD=0.3872P PS=2.64U PD=2.64U
* device instance $13 r0 *1 31.8,1 pfet
X$13 d__t0 clk__t1 \$3__t1 \$15 pfet_03v3 L=0.28U W=0.44U AS=0.3872P AD=0.3872P
+ PS=2.64U PD=2.64U
* device instance $14 r0 *1 34.2,1 pfet
X$14 \$13__t2 \$3__t3 vdd__t1 \$15 pfet_03v3 L=0.28U W=0.44U AS=0.3872P
+ AD=0.3872P PS=2.64U PD=2.64U
* device instance $15 r0 *1 36.6,1 pfet
X$15 \$13__t3 rst_n__t2 vdd__t2 \$15 pfet_03v3 L=0.28U W=0.44U AS=0.3872P
+ AD=0.3872P PS=2.64U PD=2.64U
* device instance $16 r0 *1 39,1 pfet
X$16 \$5__t0 \$13__t1 vdd__t3 \$15 pfet_03v3 L=0.28U W=0.44U AS=0.3872P
+ AD=0.3872P PS=2.64U PD=2.64U
* device instance $17 r0 *1 41.4,1 pfet
X$17 \$5__t1 \$2__t3 \$3__t2 \$15 pfet_03v3 L=0.28U W=0.44U AS=0.3872P
+ AD=0.3872P PS=2.64U PD=2.64U
* device instance $18 r0 *1 43.8,1 pfet
X$18 \$13__t4 \$2__t4 \$6__t0 \$15 pfet_03v3 L=0.28U W=0.44U AS=0.3872P
+ AD=0.3872P PS=2.64U PD=2.64U
* device instance $19 r0 *1 46.2,1 pfet
X$19 q__t2 \$6__t2 vdd__t4 \$15 pfet_03v3 L=0.28U W=0.44U AS=0.3872P AD=0.3872P
+ PS=2.64U PD=2.64U
* device instance $20 r0 *1 48.6,1 pfet
X$20 \$8__t1 q__t1 vdd__t5 \$15 pfet_03v3 L=0.28U W=0.44U AS=0.3872P AD=0.3872P
+ PS=2.64U PD=2.64U
* device instance $21 r0 *1 51,1 pfet
X$21 \$8__t2 rst_n__t3 vdd__t6 \$15 pfet_03v3 L=0.28U W=0.44U AS=0.3872P
+ AD=0.3872P PS=2.64U PD=2.64U
* device instance $22 r0 *1 53.4,1 pfet
X$22 \$8__t3 clk__t2 \$6__t1 \$15 pfet_03v3 L=0.28U W=0.44U AS=0.3872P
+ AD=0.3872P PS=2.64U PD=2.64U
* device instance _10_t0 r0 *1 0,0
R_10_t0 \$10__t0 \$10 4.339
* device instance _10_t1 r0 *1 0,0
R_10_t1 \$10__t1 \$10 4.339
* device instance _10 r0 *1 0,0
C_10 \$10 vsubs 1.843298e-15
* device instance _13_t0 r0 *1 0,0
R_13_t0 \$13__t0 \$13 13.7070294118
* device instance _13_t1 r0 *1 0,0
R_13_t1 \$13__t1 \$13 18.3759863051
* device instance _13_t2 r0 *1 0,0
R_13_t2 \$13__t2 \$13 11.179795864
* device instance _13_t3 r0 *1 0,0
R_13_t3 \$13__t3 \$13 14.7778910846
* device instance _13_t4 r0 *1 0,0
R_13_t4 \$13__t4 \$13 25.5721767463
* device instance _13_t5 r0 *1 0,0
R_13_t5 \$13__t5 \$13 31.6975055147
* device instance _13_t6 r0 *1 0,0
R_13_t6 \$13__t6 \$13 24.5013150735
* device instance _13 r0 *1 0,0
C_13 \$13 vsubs 7.039117e-15
* device instance _2_t0 r0 *1 0,0
R_2_t0 \$2__t0 \$2 58.3770524109
* device instance _2_t1 r0 *1 0,0
R_2_t1 \$2__t1 \$2 51.8605442348
* device instance _2_t2 r0 *1 0,0
R_2_t2 \$2__t2 \$2 19.2780033543
* device instance _2_t3 r0 *1 0,0
R_2_t3 \$2__t3 \$2 51.8605442348
* device instance _2_t4 r0 *1 0,0
R_2_t4 \$2__t4 \$2 58.3770524109
* device instance _2_t5 r0 *1 0,0
R_2_t5 \$2__t5 \$2 19.2780033543
* device instance _2 r0 *1 0,0
C_2 \$2 vsubs 6.545408e-15
* device instance _3_t0 r0 *1 0,0
R_3_t0 \$3__t0 \$3 8.63188625954
* device instance _3_t1 r0 *1 0,0
R_3_t1 \$3__t1 \$3 15.4019931298
* device instance _3_t2 r0 *1 0,0
R_3_t2 \$3__t2 \$3 31.6502496183
* device instance _3_t3 r0 *1 0,0
R_3_t3 \$3__t3 \$3 19.4640572519
* device instance _3_t4 r0 *1 0,0
R_3_t4 \$3__t4 \$3 24.8801427481
* device instance _3_t5 r0 *1 0,0
R_3_t5 \$3__t5 \$3 33.0042709924
* device instance _3 r0 *1 0,0
C_3 \$3 vsubs 6.162179e-15
* device instance _5_t0 r0 *1 0,0
R_5_t0 \$5__t0 \$5 5.29150973054
* device instance _5_t1 r0 *1 0,0
R_5_t1 \$5__t1 \$5 6.11084026946
* device instance _5_t2 r0 *1 0,0
R_5_t2 \$5__t2 \$5 5.29150973054
* device instance _5_t3 r0 *1 0,0
R_5_t3 \$5__t3 \$5 6.11084026946
* device instance _5 r0 *1 0,0
C_5 \$5 vsubs 4.96924e-15
* device instance _6_t0 r0 *1 0,0
R_6_t0 \$6__t0 \$6 18.3581485714
* device instance _6_t1 r0 *1 0,0
R_6_t1 \$6__t1 \$6 31.412832
* device instance _6_t2 r0 *1 0,0
R_6_t2 \$6__t2 \$6 21.6218194286
* device instance _6_t3 r0 *1 0,0
R_6_t3 \$6__t3 \$6 23.7976
* device instance _6_t4 r0 *1 0,0
R_6_t4 \$6__t4 \$6 20.5339291429
* device instance _6_t5 r0 *1 0,0
R_6_t5 \$6__t5 \$6 27.0612708571
* device instance _6 r0 *1 0,0
C_6 \$6 vsubs 7.762096e-15
* device instance _8_t0 r0 *1 0,0
R_8_t0 \$8__t0 \$8 5.80978897516
* device instance _8_t1 r0 *1 0,0
R_8_t1 \$8__t1 \$8 3.8731926501
* device instance _8_t2 r0 *1 0,0
R_8_t2 \$8__t2 \$8 4.76018333333
* device instance _8_t3 r0 *1 0,0
R_8_t3 \$8__t3 \$8 5.64717401656
* device instance _8_t4 r0 *1 0,0
R_8_t4 \$8__t4 \$8 8.47076102484
* device instance _8 r0 *1 0,0
C_8 \$8 vsubs 6.163227e-15
* device instance _9_t0 r0 *1 0,0
R_9_t0 \$9__t0 \$9 3.7545
* device instance _9_t1 r0 *1 0,0
R_9_t1 \$9__t1 \$9 3.7545
* device instance _9 r0 *1 0,0
C_9 \$9 vsubs 1.600958e-15
* device instance clk_t0 r0 *1 0,0
Rclk_t0 clk__t0 clk 28.2565785115
* device instance clk_t1 r0 *1 0,0
Rclk_t1 clk__t1 clk 37.8080980084
* device instance clk_t2 r0 *1 0,0
Rclk_t2 clk__t2 clk 123.77177348
* device instance clk_t3 r0 *1 0,0
Rclk_t3 clk__t3 clk 85.5656954927
* device instance clk_t4 r0 *1 0,0
Rclk_t4 clk__t4 clk 47.3596175052
* device instance clk_t5 r0 *1 0,0
Rclk_t5 clk__t5 clk 56.9111370021
* device instance clk r0 *1 0,0
Cclk clk vsubs 6.364731e-15
* device instance d_t0 r0 *1 0,0
Rd_t0 d__t0 d 5.48635
* device instance d_t1 r0 *1 0,0
Rd_t1 d__t1 d 5.48635
* device instance d r0 *1 0,0
Cd d vsubs 2.502323e-15
* device instance q_t0 r0 *1 0,0
Rq_t0 q__t0 q 20.939825
* device instance q_t1 r0 *1 0,0
Rq_t1 q__t1 q 33.379325
* device instance q_t2 r0 *1 0,0
Rq_t2 q__t2 q 28.403525
* device instance q_t3 r0 *1 0,0
Rq_t3 q__t3 q 40.843025
* device instance q r0 *1 0,0
Cq q vsubs 4.232351e-15
* device instance rst_n_t0 r0 *1 0,0
Rrst_n_t0 rst_n__t0 rst_n 47.0531266355
* device instance rst_n_t1 r0 *1 0,0
Rrst_n_t1 rst_n__t1 rst_n 74.2645733645
* device instance rst_n_t2 r0 *1 0,0
Rrst_n_t2 rst_n__t2 rst_n 19.8416799065
* device instance rst_n_t3 r0 *1 0,0
Rrst_n_t3 rst_n__t3 rst_n 101.476020093
* device instance rst_n r0 *1 0,0
Crst_n rst_n vsubs 4.109828e-15
* device instance vdd_t0 r0 *1 0,0
Rvdd_t0 vdd__t0 vdd 5.03077826087
* device instance vdd_t1 r0 *1 0,0
Rvdd_t1 vdd__t1 vdd 2.89650869565
* device instance vdd_t2 r0 *1 0,0
Rvdd_t2 vdd__t2 vdd 1.82937391304
* device instance vdd_t3 r0 *1 0,0
Rvdd_t3 vdd__t3 vdd 0.762239130435
* device instance vdd_t4 r0 *1 0,0
Rvdd_t4 vdd__t4 vdd 2.43916521739
* device instance vdd_t5 r0 *1 0,0
Rvdd_t5 vdd__t5 vdd 3.5063
* device instance vdd_t6 r0 *1 0,0
Rvdd_t6 vdd__t6 vdd 4.57343478261
* device instance vdd r0 *1 0,0
Cvdd vdd vsubs 4.333334e-15
* device instance vss_t0 r0 *1 0,0
Rvss_t0 vss__t0 vss 5.773625
* device instance vss_t1 r0 *1 0,0
Rvss_t1 vss__t1 vss 3.464175
* device instance vss_t2 r0 *1 0,0
Rvss_t2 vss__t2 vss 5.773625
* device instance vss_t3 r0 *1 0,0
Rvss_t3 vss__t3 vss 0.001
* device instance vss_t4 r0 *1 0,0
Rvss_t4 vss__t4 vss 3.464175
* device instance vss r0 *1 0,0
Cvss vss vsubs 3.913891e-15
* device instance cc__10__13 r0 *1 0,0
Ccc__10__13 \$10 \$13 1.0625e-17
* device instance cc__10__2 r0 *1 0,0
Ccc__10__2 \$10 \$2 1.0625e-17
* device instance cc__10__3 r0 *1 0,0
Ccc__10__3 \$10 \$3 1.0625e-17
* device instance cc__10__5 r0 *1 0,0
Ccc__10__5 \$10 \$5 1.0625e-17
* device instance cc__10__6 r0 *1 0,0
Ccc__10__6 \$10 \$6 1.0625e-17
* device instance cc__10__8 r0 *1 0,0
Ccc__10__8 \$10 \$8 1.0625e-17
* device instance cc__10_clk r0 *1 0,0
Ccc__10_clk \$10 clk 1.0625e-17
* device instance cc__10_d r0 *1 0,0
Ccc__10_d \$10 d 1.0625e-17
* device instance cc__10_q r0 *1 0,0
Ccc__10_q \$10 q 1.0625e-17
* device instance cc__10_rst_n r0 *1 0,0
Ccc__10_rst_n \$10 rst_n 1.0625e-17
* device instance cc__10_vss r0 *1 0,0
Ccc__10_vss \$10 vss 5.312e-18
* device instance cc__13__2 r0 *1 0,0
Ccc__13__2 \$13 \$2 3.1875e-17
* device instance cc__13__3 r0 *1 0,0
Ccc__13__3 \$13 \$3 3.1875e-17
* device instance cc__13__5 r0 *1 0,0
Ccc__13__5 \$13 \$5 2.125e-17
* device instance cc__13__6 r0 *1 0,0
Ccc__13__6 \$13 \$6 2.125e-17
* device instance cc__13__8 r0 *1 0,0
Ccc__13__8 \$13 \$8 1.0625e-17
* device instance cc__13__9 r0 *1 0,0
Ccc__13__9 \$13 \$9 1.0625e-17
* device instance cc__13_clk r0 *1 0,0
Ccc__13_clk \$13 clk 3.7187e-17
* device instance cc__13_d r0 *1 0,0
Ccc__13_d \$13 d 1.5937e-17
* device instance cc__13_q r0 *1 0,0
Ccc__13_q \$13 q 2.6562e-17
* device instance cc__13_rst_n r0 *1 0,0
Ccc__13_rst_n \$13 rst_n 2.125e-17
* device instance cc__13_vdd r0 *1 0,0
Ccc__13_vdd \$13 vdd 2.125e-17
* device instance cc__13_vss r0 *1 0,0
Ccc__13_vss \$13 vss 1.5937e-17
* device instance cc__2__3 r0 *1 0,0
Ccc__2__3 \$2 \$3 3.1875e-17
* device instance cc__2__5 r0 *1 0,0
Ccc__2__5 \$2 \$5 2.125e-17
* device instance cc__2__6 r0 *1 0,0
Ccc__2__6 \$2 \$6 2.125e-17
* device instance cc__2__8 r0 *1 0,0
Ccc__2__8 \$2 \$8 1.0625e-17
* device instance cc__2__9 r0 *1 0,0
Ccc__2__9 \$2 \$9 1.0625e-17
* device instance cc__2_clk r0 *1 0,0
Ccc__2_clk \$2 clk 3.1875e-17
* device instance cc__2_d r0 *1 0,0
Ccc__2_d \$2 d 1.0625e-17
* device instance cc__2_q r0 *1 0,0
Ccc__2_q \$2 q 2.125e-17
* device instance cc__2_rst_n r0 *1 0,0
Ccc__2_rst_n \$2 rst_n 1.5937e-17
* device instance cc__2_vdd r0 *1 0,0
Ccc__2_vdd \$2 vdd 1.5937e-17
* device instance cc__2_vss r0 *1 0,0
Ccc__2_vss \$2 vss 1.5937e-17
* device instance cc__3__5 r0 *1 0,0
Ccc__3__5 \$3 \$5 1.5937e-17
* device instance cc__3__6 r0 *1 0,0
Ccc__3__6 \$3 \$6 1.5937e-17
* device instance cc__3__8 r0 *1 0,0
Ccc__3__8 \$3 \$8 1.0625e-17
* device instance cc__3__9 r0 *1 0,0
Ccc__3__9 \$3 \$9 1.0625e-17
* device instance cc__3_clk r0 *1 0,0
Ccc__3_clk \$3 clk 3.1875e-17
* device instance cc__3_d r0 *1 0,0
Ccc__3_d \$3 d 1.5937e-17
* device instance cc__3_q r0 *1 0,0
Ccc__3_q \$3 q 2.125e-17
* device instance cc__3_rst_n r0 *1 0,0
Ccc__3_rst_n \$3 rst_n 1.5937e-17
* device instance cc__3_vdd r0 *1 0,0
Ccc__3_vdd \$3 vdd 1.5937e-17
* device instance cc__3_vss r0 *1 0,0
Ccc__3_vss \$3 vss 1.5937e-17
* device instance cc__5__6 r0 *1 0,0
Ccc__5__6 \$5 \$6 1.5937e-17
* device instance cc__5__8 r0 *1 0,0
Ccc__5__8 \$5 \$8 1.0625e-17
* device instance cc__5__9 r0 *1 0,0
Ccc__5__9 \$5 \$9 1.0625e-17
* device instance cc__5_clk r0 *1 0,0
Ccc__5_clk \$5 clk 2.125e-17
* device instance cc__5_d r0 *1 0,0
Ccc__5_d \$5 d 1.0625e-17
* device instance cc__5_q r0 *1 0,0
Ccc__5_q \$5 q 1.0625e-17
* device instance cc__5_rst_n r0 *1 0,0
Ccc__5_rst_n \$5 rst_n 1.0625e-17
* device instance cc__5_vdd r0 *1 0,0
Ccc__5_vdd \$5 vdd 1.0625e-17
* device instance cc__5_vss r0 *1 0,0
Ccc__5_vss \$5 vss 1.0625e-17
* device instance cc__6__8 r0 *1 0,0
Ccc__6__8 \$6 \$8 1.5937e-17
* device instance cc__6_clk r0 *1 0,0
Ccc__6_clk \$6 clk 3.1875e-17
* device instance cc__6_d r0 *1 0,0
Ccc__6_d \$6 d 1.5937e-17
* device instance cc__6_q r0 *1 0,0
Ccc__6_q \$6 q 1.5937e-17
* device instance cc__6_rst_n r0 *1 0,0
Ccc__6_rst_n \$6 rst_n 1.0625e-17
* device instance cc__6_vdd r0 *1 0,0
Ccc__6_vdd \$6 vdd 1.0625e-17
* device instance cc__6_vss r0 *1 0,0
Ccc__6_vss \$6 vss 1.5937e-17
* device instance cc__8_clk r0 *1 0,0
Ccc__8_clk \$8 clk 2.125e-17
* device instance cc__8_d r0 *1 0,0
Ccc__8_d \$8 d 1.0625e-17
* device instance cc__8_q r0 *1 0,0
Ccc__8_q \$8 q 1.0625e-17
* device instance cc__8_rst_n r0 *1 0,0
Ccc__8_rst_n \$8 rst_n 1.0625e-17
* device instance cc__8_vdd r0 *1 0,0
Ccc__8_vdd \$8 vdd 5.312e-18
* device instance cc__8_vss r0 *1 0,0
Ccc__8_vss \$8 vss 1.0625e-17
* device instance cc__9_clk r0 *1 0,0
Ccc__9_clk \$9 clk 1.0625e-17
* device instance cc__9_d r0 *1 0,0
Ccc__9_d \$9 d 1.0625e-17
* device instance cc__9_q r0 *1 0,0
Ccc__9_q \$9 q 1.0625e-17
* device instance cc__9_rst_n r0 *1 0,0
Ccc__9_rst_n \$9 rst_n 5.312e-18
* device instance cc__9_vss r0 *1 0,0
Ccc__9_vss \$9 vss 1.0625e-17
* device instance cc_clk_d r0 *1 0,0
Ccc_clk_d clk d 2.125e-17
* device instance cc_clk_q r0 *1 0,0
Ccc_clk_q clk q 2.125e-17
* device instance cc_clk_rst_n r0 *1 0,0
Ccc_clk_rst_n clk rst_n 2.125e-17
* device instance cc_clk_vdd r0 *1 0,0
Ccc_clk_vdd clk vdd 3.7187e-17
* device instance cc_clk_vss r0 *1 0,0
Ccc_clk_vss clk vss 2.125e-17
* device instance cc_d_q r0 *1 0,0
Ccc_d_q d q 1.0625e-17
* device instance cc_d_rst_n r0 *1 0,0
Ccc_d_rst_n d rst_n 1.0625e-17
* device instance cc_d_vdd r0 *1 0,0
Ccc_d_vdd d vdd 5.312e-18
* device instance cc_d_vss r0 *1 0,0
Ccc_d_vss d vss 2.125e-17
* device instance cc_q_rst_n r0 *1 0,0
Ccc_q_rst_n q rst_n 1.5937e-17
* device instance cc_q_vdd r0 *1 0,0
Ccc_q_vdd q vdd 3.1875e-17
* device instance cc_q_vss r0 *1 0,0
Ccc_q_vss q vss 1.0625e-17
* device instance cc_rst_n_vdd r0 *1 0,0
Ccc_rst_n_vdd rst_n vdd 3.7187e-17
* device instance cc_rst_n_vss r0 *1 0,0
Ccc_rst_n_vss rst_n vss 5.312e-18
* device instance vsubs_dctie r0 *1 0,0
Rvsubs_dctie vsubs 0 1e+12
.ENDS sampler_dff
