* extracted by klt extract --deck gf180mcu
* parasitic model (--parasitics):
* - capacitance: net-to-ground for every net's own (non-coupled) area/perimeter, plus net-to-net for the vertical-overlap coupling `coupling` describes below -- a coupled net pair gets a direct capacitor between their two hub nodes, not just capacitors to the deck's ground/substrate net
* - coupling: vertical overlap (crossover) unconditionally -- where one net's conductor on an adjacent metal level sits directly over another *distinct* net's conductor, that overlap area is charged between the two nets instead of to ground (issue #760) -- plus lateral (same-layer, sidewall) coupling, but only for a net pair naming one of the caller's declared `--critical-net` nets (issue #976): facing-edge length within that layer's own minimum-spacing lookback is charged between the two nets, *additively* (not deducted from either net's substrate fringe term, unlike the vertical case -- a known simplification). Any same-layer pair with neither side named `--critical-net`, and fringe shielding in general, are still not modelled
* - resistance: single lumped series resistance per net, distributed as a star across that net's device terminals (issue #592) -- not a per-segment, distributed RC ladder, *unless* `--distributed-rc` names this net via `--critical-net` (issue #977, Epic #709 Phase 2b): then the net's terminals are ordered along their approximate physical spread and its total R/C is broken into a chain of per-segment resistors (segment length proportional to inter-terminal distance) with a ground capacitor at each terminal node (proportional to its adjacent segment length/2), instead of one star hub -- still an approximation (terminal position is a device-placement proxy, not true per-segment routing geometry), but a strictly finer-grained one than the single-hub star
* - frequency: quasi-static -- one frequency-independent R and C per net; no skin effect, no distributed transmission-line behavior
* - substrate tie: 1e+12 ohm to ground -- the substrate is capacitively floating in transient analysis (DC reference only); see --substrate-tie-ohms
.GLOBAL vsubs

* cell sampler_dff
* pin clk
* pin d
* pin q
* pin rst_n
* pin vdd
* pin vss
.SUBCKT sampler_dff clk d q rst_n vdd vss
* device instance $1 r0 *1 0.8,1 nfet
X$1 \$3__t0 clk__t3 vss__t0 vss__t5 nfet_03v3 L=0.28U W=0.22U AS=0.3872P
+ AD=0.3872P PS=2.64U PD=2.64U
* device instance $2 r0 *1 3.2,1 nfet
X$2 d__t1 \$3__t1 \$4__t3 vss__t6 nfet_03v3 L=0.28U W=0.22U AS=0.3872P
+ AD=0.3872P PS=2.64U PD=2.64U
* device instance $3 r0 *1 5.6,1 nfet
X$3 \$6__t3 \$13__t5 vss__t4 vss__t7 nfet_03v3 L=0.28U W=0.22U AS=0.3872P
+ AD=0.3872P PS=2.64U PD=2.64U
* device instance $4 r0 *1 8,1 nfet
X$4 \$6__t2 clk__t5 \$4__t2 vss__t8 nfet_03v3 L=0.28U W=0.22U AS=0.3872P
+ AD=0.3872P PS=2.64U PD=2.64U
* device instance $5 r0 *1 10.4,1 nfet
X$5 \$13__t6 clk__t4 \$7__t3 vss__t9 nfet_03v3 L=0.28U W=0.22U AS=0.3872P
+ AD=0.3872P PS=2.64U PD=2.64U
* device instance $6 r0 *1 12.8,1 nfet
X$6 q__t3 \$7__t1 vss__t3 vss__t10 nfet_03v3 L=0.28U W=0.22U AS=0.3872P
+ AD=0.3872P PS=2.64U PD=2.64U
* device instance $7 r0 *1 15.2,1 nfet
X$7 \$9__t4 \$3__t5 \$7__t2 vss__t11 nfet_03v3 L=0.28U W=0.22U AS=0.3872P
+ AD=0.3872P PS=2.64U PD=2.64U
* device instance $8 r0 *1 17.6,1 nfet
X$8 \$13__t0 \$4__t0 \$10__t1 vss__t12 nfet_03v3 L=0.28U W=0.44U AS=0.3872P
+ AD=0.3872P PS=2.64U PD=2.64U
* device instance $9 r0 *1 20,1 nfet
X$9 \$10__t0 rst_n__t1 vss__t1 vss__t13 nfet_03v3 L=0.28U W=0.44U AS=0.3872P
+ AD=0.3872P PS=2.64U PD=2.64U
* device instance $10 r0 *1 22.4,1 nfet
X$10 \$9__t0 q__t0 \$11__t1 vss__t14 nfet_03v3 L=0.28U W=0.44U AS=0.3872P
+ AD=0.3872P PS=2.64U PD=2.64U
* device instance $11 r0 *1 24.8,1 nfet
X$11 \$11__t0 rst_n__t0 vss__t2 vss__t15 nfet_03v3 L=0.28U W=0.44U AS=0.3872P
+ AD=0.3872P PS=2.64U PD=2.64U
* device instance $12 r0 *1 29.4,1 pfet
X$12 \$3__t2 clk__t0 vdd__t0 vdd__t1 pfet_03v3 L=0.28U W=0.44U AS=0.3872P
+ AD=0.3872P PS=2.64U PD=2.64U
* device instance $13 r0 *1 31.8,1 pfet
X$13 d__t0 clk__t1 \$4__t4 vdd__t2 pfet_03v3 L=0.28U W=0.44U AS=0.3872P
+ AD=0.3872P PS=2.64U PD=2.64U
* device instance $14 r0 *1 34.2,1 pfet
X$14 \$13__t2 \$4__t1 vdd__t12 vdd__t3 pfet_03v3 L=0.28U W=0.44U AS=0.3872P
+ AD=0.3872P PS=2.64U PD=2.64U
* device instance $15 r0 *1 36.6,1 pfet
X$15 \$13__t3 rst_n__t2 vdd__t13 vdd__t4 pfet_03v3 L=0.28U W=0.44U AS=0.3872P
+ AD=0.3872P PS=2.64U PD=2.64U
* device instance $16 r0 *1 39,1 pfet
X$16 \$6__t0 \$13__t1 vdd__t14 vdd__t5 pfet_03v3 L=0.28U W=0.44U AS=0.3872P
+ AD=0.3872P PS=2.64U PD=2.64U
* device instance $17 r0 *1 41.4,1 pfet
X$17 \$6__t1 \$3__t3 \$4__t5 vdd__t6 pfet_03v3 L=0.28U W=0.44U AS=0.3872P
+ AD=0.3872P PS=2.64U PD=2.64U
* device instance $18 r0 *1 43.8,1 pfet
X$18 \$13__t4 \$3__t4 \$7__t4 vdd__t7 pfet_03v3 L=0.28U W=0.44U AS=0.3872P
+ AD=0.3872P PS=2.64U PD=2.64U
* device instance $19 r0 *1 46.2,1 pfet
X$19 q__t2 \$7__t0 vdd__t15 vdd__t8 pfet_03v3 L=0.28U W=0.44U AS=0.3872P
+ AD=0.3872P PS=2.64U PD=2.64U
* device instance $20 r0 *1 48.6,1 pfet
X$20 \$9__t1 q__t1 vdd__t16 vdd__t9 pfet_03v3 L=0.28U W=0.44U AS=0.3872P
+ AD=0.3872P PS=2.64U PD=2.64U
* device instance $21 r0 *1 51,1 pfet
X$21 \$9__t2 rst_n__t3 vdd__t17 vdd__t10 pfet_03v3 L=0.28U W=0.44U AS=0.3872P
+ AD=0.3872P PS=2.64U PD=2.64U
* device instance $22 r0 *1 53.4,1 pfet
X$22 \$9__t3 clk__t2 \$7__t5 vdd__t11 pfet_03v3 L=0.28U W=0.44U AS=0.3872P
+ AD=0.3872P PS=2.64U PD=2.64U
* device instance _10_t0 r0 *1 0,0
R_10_t0 \$10__t0 \$10 3.276
* device instance _10_t1 r0 *1 0,0
R_10_t1 \$10__t1 \$10 3.276
* device instance _10 r0 *1 0,0
C_10 \$10 vsubs 1.600958e-15
* device instance _11_t0 r0 *1 0,0
R_11_t0 \$11__t0 \$11 3.861
* device instance _11_t1 r0 *1 0,0
R_11_t1 \$11__t1 \$11 3.861
* device instance _11 r0 *1 0,0
C_11 \$11 vsubs 1.843298e-15
* device instance _13_t0 r0 *1 0,0
R_13_t0 \$13__t0 \$13 8.82941176471
* device instance _13_t1 r0 *1 0,0
R_13_t1 \$13__t1 \$13 11.8369301471
* device instance _13_t2 r0 *1 0,0
R_13_t2 \$13__t2 \$13 7.20148897059
* device instance _13_t3 r0 *1 0,0
R_13_t3 \$13__t3 \$13 9.51920955882
* device instance _13_t4 r0 *1 0,0
R_13_t4 \$13__t4 \$13 16.4723713235
* device instance _13_t5 r0 *1 0,0
R_13_t5 \$13__t5 \$13 20.4180147059
* device instance _13_t6 r0 *1 0,0
R_13_t6 \$13__t6 \$13 15.7825735294
* device instance _13 r0 *1 0,0
C_13 \$13 vsubs 7.039117e-15
* device instance _3_t0 r0 *1 0,0
R_3_t0 \$3__t0 \$3 33.5846001048
* device instance _3_t1 r0 *1 0,0
R_3_t1 \$3__t1 \$3 29.8356214885
* device instance _3_t2 r0 *1 0,0
R_3_t2 \$3__t2 \$3 11.0907284067
* device instance _3_t3 r0 *1 0,0
R_3_t3 \$3__t3 \$3 29.8356214885
* device instance _3_t4 r0 *1 0,0
R_3_t4 \$3__t4 \$3 33.5846001048
* device instance _3_t5 r0 *1 0,0
R_3_t5 \$3__t5 \$3 11.0907284067
* device instance _3 r0 *1 0,0
C_3 \$3 vsubs 6.545408e-15
* device instance _4_t0 r0 *1 0,0
R_4_t0 \$4__t0 \$4 5.40203549618
* device instance _4_t1 r0 *1 0,0
R_4_t1 \$4__t1 \$4 12.1810604326
* device instance _4_t2 r0 *1 0,0
R_4_t2 \$4__t2 \$4 15.5705729008
* device instance _4_t3 r0 *1 0,0
R_4_t3 \$4__t3 \$4 20.6548416031
* device instance _4_t4 r0 *1 0,0
R_4_t4 \$4__t4 \$4 9.63892608142
* device instance _4_t5 r0 *1 0,0
R_4_t5 \$4__t5 \$4 19.807463486
* device instance _4 r0 *1 0,0
C_4 \$4 vsubs 6.162179e-15
* device instance _6_t0 r0 *1 0,0
R_6_t0 \$6__t0 \$6 4.77390718563
* device instance _6_t1 r0 *1 0,0
R_6_t1 \$6__t1 \$6 5.51309281437
* device instance _6_t2 r0 *1 0,0
R_6_t2 \$6__t2 \$6 4.77390718563
* device instance _6_t3 r0 *1 0,0
R_6_t3 \$6__t3 \$6 5.51309281437
* device instance _6 r0 *1 0,0
C_6 \$6 vsubs 4.96924e-15
* device instance _7_t0 r0 *1 0,0
R_7_t0 \$7__t0 \$7 14.1887057143
* device instance _7_t1 r0 *1 0,0
R_7_t1 \$7__t1 \$7 15.6165
* device instance _7_t2 r0 *1 0,0
R_7_t2 \$7__t2 \$7 13.4748085714
* device instance _7_t3 r0 *1 0,0
R_7_t3 \$7__t3 \$7 17.7581914286
* device instance _7_t4 r0 *1 0,0
R_7_t4 \$7__t4 \$7 12.0470142857
* device instance _7_t5 r0 *1 0,0
R_7_t5 \$7__t5 \$7 20.61378
* device instance _7 r0 *1 0,0
C_7 \$7 vsubs 7.762096e-15
* device instance _9_t0 r0 *1 0,0
R_9_t0 \$9__t0 \$9 5.22372670807
* device instance _9_t1 r0 *1 0,0
R_9_t1 \$9__t1 \$9 3.48248447205
* device instance _9_t2 r0 *1 0,0
R_9_t2 \$9__t2 \$9 4.28
* device instance _9_t3 r0 *1 0,0
R_9_t3 \$9__t3 \$9 5.07751552795
* device instance _9_t4 r0 *1 0,0
R_9_t4 \$9__t4 \$9 7.61627329193
* device instance _9 r0 *1 0,0
C_9 \$9 vsubs 6.163227e-15
* device instance clk_t0 r0 *1 0,0
Rclk_t0 clk__t0 clk 15.5451969602
* device instance clk_t1 r0 *1 0,0
Rclk_t1 clk__t1 clk 20.7999114256
* device instance clk_t2 r0 *1 0,0
Rclk_t2 clk__t2 clk 68.0923416143
* device instance clk_t3 r0 *1 0,0
Rclk_t3 clk__t3 clk 47.0734837526
* device instance clk_t4 r0 *1 0,0
Rclk_t4 clk__t4 clk 26.054625891
* device instance clk_t5 r0 *1 0,0
Rclk_t5 clk__t5 clk 31.3093403564
* device instance clk r0 *1 0,0
Cclk clk vsubs 6.364731e-15
* device instance d_t0 r0 *1 0,0
Rd_t0 d__t0 d 5.016
* device instance d_t1 r0 *1 0,0
Rd_t1 d__t1 d 5.016
* device instance d r0 *1 0,0
Cd d vsubs 2.502323e-15
* device instance q_t0 r0 *1 0,0
Rq_t0 q__t0 q 12.7237800336
* device instance q_t1 r0 *1 0,0
Rq_t1 q__t1 q 20.2824612416
* device instance q_t2 r0 *1 0,0
Rq_t2 q__t2 q 17.2589887584
* device instance q_t3 r0 *1 0,0
Rq_t3 q__t3 q 24.8176699664
* device instance q r0 *1 0,0
Cq q vsubs 4.232351e-15
* device instance rst_n_t0 r0 *1 0,0
Rrst_n_t0 rst_n__t0 rst_n 25.7012602804
* device instance rst_n_t1 r0 *1 0,0
Rrst_n_t1 rst_n__t1 rst_n 40.5646397196
* device instance rst_n_t2 r0 *1 0,0
Rrst_n_t2 rst_n__t2 rst_n 10.8378808411
* device instance rst_n_t3 r0 *1 0,0
Rrst_n_t3 rst_n__t3 rst_n 55.4280191589
* device instance rst_n r0 *1 0,0
Crst_n rst_n vsubs 4.109828e-15
* device instance vdd_t0 r0 *1 0,0
Rvdd_t0 vdd__t0 vdd 1.72117244444
* device instance vdd_t1 r0 *1 0,0
Rvdd_t1 vdd__t1 vdd 1.72117244444
* device instance vdd_t2 r0 *1 0,0
Rvdd_t2 vdd__t2 vdd 1.36911444444
* device instance vdd_t3 r0 *1 0,0
Rvdd_t3 vdd__t3 vdd 1.01705644444
* device instance vdd_t4 r0 *1 0,0
Rvdd_t4 vdd__t4 vdd 0.664998444444
* device instance vdd_t5 r0 *1 0,0
Rvdd_t5 vdd__t5 vdd 0.312940444444
* device instance vdd_t6 r0 *1 0,0
Rvdd_t6 vdd__t6 vdd 0.0391175555556
* device instance vdd_t7 r0 *1 0,0
Rvdd_t7 vdd__t7 vdd 0.391175555556
* device instance vdd_t8 r0 *1 0,0
Rvdd_t8 vdd__t8 vdd 0.743233555556
* device instance vdd_t9 r0 *1 0,0
Rvdd_t9 vdd__t9 vdd 1.09529155556
* device instance vdd_t10 r0 *1 0,0
Rvdd_t10 vdd__t10 vdd 1.44734955556
* device instance vdd_t11 r0 *1 0,0
Rvdd_t11 vdd__t11 vdd 1.79940755556
* device instance vdd_t12 r0 *1 0,0
Rvdd_t12 vdd__t12 vdd 1.01705644444
* device instance vdd_t13 r0 *1 0,0
Rvdd_t13 vdd__t13 vdd 0.664998444444
* device instance vdd_t14 r0 *1 0,0
Rvdd_t14 vdd__t14 vdd 0.312940444444
* device instance vdd_t15 r0 *1 0,0
Rvdd_t15 vdd__t15 vdd 0.743233555556
* device instance vdd_t16 r0 *1 0,0
Rvdd_t16 vdd__t16 vdd 1.09529155556
* device instance vdd_t17 r0 *1 0,0
Rvdd_t17 vdd__t17 vdd 1.44734955556
* device instance vdd r0 *1 0,0
Cvdd vdd vsubs 4.542446e-15
* device instance vss_t0 r0 *1 0,0
Rvss_t0 vss__t0 vss 1.77998913043
* device instance vss_t1 r0 *1 0,0
Rvss_t1 vss__t1 vss 1.06799347826
* device instance vss_t2 r0 *1 0,0
Rvss_t2 vss__t2 vss 1.77998913043
* device instance vss_t3 r0 *1 0,0
Rvss_t3 vss__t3 vss 0.001
* device instance vss_t4 r0 *1 0,0
Rvss_t4 vss__t4 vss 1.06799347826
* device instance vss_t5 r0 *1 0,0
Rvss_t5 vss__t5 vss 1.77998913043
* device instance vss_t6 r0 *1 0,0
Rvss_t6 vss__t6 vss 1.42399130435
* device instance vss_t7 r0 *1 0,0
Rvss_t7 vss__t7 vss 1.06799347826
* device instance vss_t8 r0 *1 0,0
Rvss_t8 vss__t8 vss 0.711995652174
* device instance vss_t9 r0 *1 0,0
Rvss_t9 vss__t9 vss 0.355997826087
* device instance vss_t10 r0 *1 0,0
Rvss_t10 vss__t10 vss 0.001
* device instance vss_t11 r0 *1 0,0
Rvss_t11 vss__t11 vss 0.355997826087
* device instance vss_t12 r0 *1 0,0
Rvss_t12 vss__t12 vss 0.711995652174
* device instance vss_t13 r0 *1 0,0
Rvss_t13 vss__t13 vss 1.06799347826
* device instance vss_t14 r0 *1 0,0
Rvss_t14 vss__t14 vss 1.42399130435
* device instance vss_t15 r0 *1 0,0
Rvss_t15 vss__t15 vss 1.77998913043
* device instance vss r0 *1 0,0
Cvss vss vsubs 4.123003e-15
* device instance cc__10__13 r0 *1 0,0
Ccc__10__13 \$10 \$13 1.0625e-17
* device instance cc__10__3 r0 *1 0,0
Ccc__10__3 \$10 \$3 1.0625e-17
* device instance cc__10__4 r0 *1 0,0
Ccc__10__4 \$10 \$4 1.0625e-17
* device instance cc__10__6 r0 *1 0,0
Ccc__10__6 \$10 \$6 1.0625e-17
* device instance cc__10_clk r0 *1 0,0
Ccc__10_clk \$10 clk 1.0625e-17
* device instance cc__10_d r0 *1 0,0
Ccc__10_d \$10 d 1.0625e-17
* device instance cc__10_q r0 *1 0,0
Ccc__10_q \$10 q 1.0625e-17
* device instance cc__10_rst_n r0 *1 0,0
Ccc__10_rst_n \$10 rst_n 5.312e-18
* device instance cc__10_vss r0 *1 0,0
Ccc__10_vss \$10 vss 1.0625e-17
* device instance cc__11__13 r0 *1 0,0
Ccc__11__13 \$11 \$13 1.0625e-17
* device instance cc__11__3 r0 *1 0,0
Ccc__11__3 \$11 \$3 1.0625e-17
* device instance cc__11__4 r0 *1 0,0
Ccc__11__4 \$11 \$4 1.0625e-17
* device instance cc__11__6 r0 *1 0,0
Ccc__11__6 \$11 \$6 1.0625e-17
* device instance cc__11__7 r0 *1 0,0
Ccc__11__7 \$11 \$7 1.0625e-17
* device instance cc__11__9 r0 *1 0,0
Ccc__11__9 \$11 \$9 1.0625e-17
* device instance cc__11_clk r0 *1 0,0
Ccc__11_clk \$11 clk 1.0625e-17
* device instance cc__11_d r0 *1 0,0
Ccc__11_d \$11 d 1.0625e-17
* device instance cc__11_q r0 *1 0,0
Ccc__11_q \$11 q 1.0625e-17
* device instance cc__11_rst_n r0 *1 0,0
Ccc__11_rst_n \$11 rst_n 1.0625e-17
* device instance cc__11_vss r0 *1 0,0
Ccc__11_vss \$11 vss 5.312e-18
* device instance cc__13__3 r0 *1 0,0
Ccc__13__3 \$13 \$3 3.1875e-17
* device instance cc__13__4 r0 *1 0,0
Ccc__13__4 \$13 \$4 3.1875e-17
* device instance cc__13__6 r0 *1 0,0
Ccc__13__6 \$13 \$6 2.125e-17
* device instance cc__13__7 r0 *1 0,0
Ccc__13__7 \$13 \$7 2.125e-17
* device instance cc__13__9 r0 *1 0,0
Ccc__13__9 \$13 \$9 1.0625e-17
* device instance cc__13_clk r0 *1 0,0
Ccc__13_clk \$13 clk 3.7187e-17
* device instance cc__13_d r0 *1 0,0
Ccc__13_d \$13 d 1.5937e-17
* device instance cc__13_q r0 *1 0,0
Ccc__13_q \$13 q 2.6562e-17
* device instance cc__13_rst_n r0 *1 0,0
Ccc__13_rst_n \$13 rst_n 2.125e-17
* device instance cc__13_vdd r0 *1 0,0
Ccc__13_vdd \$13 vdd 2.125e-17
* device instance cc__13_vss r0 *1 0,0
Ccc__13_vss \$13 vss 1.5937e-17
* device instance cc__3__4 r0 *1 0,0
Ccc__3__4 \$3 \$4 3.1875e-17
* device instance cc__3__6 r0 *1 0,0
Ccc__3__6 \$3 \$6 2.125e-17
* device instance cc__3__7 r0 *1 0,0
Ccc__3__7 \$3 \$7 2.125e-17
* device instance cc__3__9 r0 *1 0,0
Ccc__3__9 \$3 \$9 1.0625e-17
* device instance cc__3_clk r0 *1 0,0
Ccc__3_clk \$3 clk 3.1875e-17
* device instance cc__3_d r0 *1 0,0
Ccc__3_d \$3 d 1.0625e-17
* device instance cc__3_q r0 *1 0,0
Ccc__3_q \$3 q 2.125e-17
* device instance cc__3_rst_n r0 *1 0,0
Ccc__3_rst_n \$3 rst_n 1.5937e-17
* device instance cc__3_vdd r0 *1 0,0
Ccc__3_vdd \$3 vdd 1.5937e-17
* device instance cc__3_vss r0 *1 0,0
Ccc__3_vss \$3 vss 1.5937e-17
* device instance cc__4__6 r0 *1 0,0
Ccc__4__6 \$4 \$6 1.5937e-17
* device instance cc__4__7 r0 *1 0,0
Ccc__4__7 \$4 \$7 1.5937e-17
* device instance cc__4__9 r0 *1 0,0
Ccc__4__9 \$4 \$9 1.0625e-17
* device instance cc__4_clk r0 *1 0,0
Ccc__4_clk \$4 clk 3.1875e-17
* device instance cc__4_d r0 *1 0,0
Ccc__4_d \$4 d 1.5937e-17
* device instance cc__4_q r0 *1 0,0
Ccc__4_q \$4 q 2.125e-17
* device instance cc__4_rst_n r0 *1 0,0
Ccc__4_rst_n \$4 rst_n 1.5937e-17
* device instance cc__4_vdd r0 *1 0,0
Ccc__4_vdd \$4 vdd 1.5937e-17
* device instance cc__4_vss r0 *1 0,0
Ccc__4_vss \$4 vss 1.5937e-17
* device instance cc__6__7 r0 *1 0,0
Ccc__6__7 \$6 \$7 1.5937e-17
* device instance cc__6__9 r0 *1 0,0
Ccc__6__9 \$6 \$9 1.0625e-17
* device instance cc__6_clk r0 *1 0,0
Ccc__6_clk \$6 clk 2.125e-17
* device instance cc__6_d r0 *1 0,0
Ccc__6_d \$6 d 1.0625e-17
* device instance cc__6_q r0 *1 0,0
Ccc__6_q \$6 q 1.0625e-17
* device instance cc__6_rst_n r0 *1 0,0
Ccc__6_rst_n \$6 rst_n 1.0625e-17
* device instance cc__6_vdd r0 *1 0,0
Ccc__6_vdd \$6 vdd 1.0625e-17
* device instance cc__6_vss r0 *1 0,0
Ccc__6_vss \$6 vss 1.0625e-17
* device instance cc__7__9 r0 *1 0,0
Ccc__7__9 \$7 \$9 1.5937e-17
* device instance cc__7_clk r0 *1 0,0
Ccc__7_clk \$7 clk 3.1875e-17
* device instance cc__7_d r0 *1 0,0
Ccc__7_d \$7 d 1.5937e-17
* device instance cc__7_q r0 *1 0,0
Ccc__7_q \$7 q 1.5937e-17
* device instance cc__7_rst_n r0 *1 0,0
Ccc__7_rst_n \$7 rst_n 1.0625e-17
* device instance cc__7_vdd r0 *1 0,0
Ccc__7_vdd \$7 vdd 1.0625e-17
* device instance cc__7_vss r0 *1 0,0
Ccc__7_vss \$7 vss 1.5937e-17
* device instance cc__9_clk r0 *1 0,0
Ccc__9_clk \$9 clk 2.125e-17
* device instance cc__9_d r0 *1 0,0
Ccc__9_d \$9 d 1.0625e-17
* device instance cc__9_q r0 *1 0,0
Ccc__9_q \$9 q 1.0625e-17
* device instance cc__9_rst_n r0 *1 0,0
Ccc__9_rst_n \$9 rst_n 1.0625e-17
* device instance cc__9_vdd r0 *1 0,0
Ccc__9_vdd \$9 vdd 5.312e-18
* device instance cc__9_vss r0 *1 0,0
Ccc__9_vss \$9 vss 1.0625e-17
* device instance cc_clk_d r0 *1 0,0
Ccc_clk_d clk d 2.125e-17
* device instance cc_clk_q r0 *1 0,0
Ccc_clk_q clk q 2.125e-17
* device instance cc_clk_rst_n r0 *1 0,0
Ccc_clk_rst_n clk rst_n 2.125e-17
* device instance cc_clk_vdd r0 *1 0,0
Ccc_clk_vdd clk vdd 3.7187e-17
* device instance cc_clk_vss r0 *1 0,0
Ccc_clk_vss clk vss 2.125e-17
* device instance cc_d_q r0 *1 0,0
Ccc_d_q d q 1.0625e-17
* device instance cc_d_rst_n r0 *1 0,0
Ccc_d_rst_n d rst_n 1.0625e-17
* device instance cc_d_vdd r0 *1 0,0
Ccc_d_vdd d vdd 5.312e-18
* device instance cc_d_vss r0 *1 0,0
Ccc_d_vss d vss 2.125e-17
* device instance cc_q_rst_n r0 *1 0,0
Ccc_q_rst_n q rst_n 1.5937e-17
* device instance cc_q_vdd r0 *1 0,0
Ccc_q_vdd q vdd 3.1875e-17
* device instance cc_q_vss r0 *1 0,0
Ccc_q_vss q vss 1.0625e-17
* device instance cc_rst_n_vdd r0 *1 0,0
Ccc_rst_n_vdd rst_n vdd 3.7187e-17
* device instance cc_rst_n_vss r0 *1 0,0
Ccc_rst_n_vss rst_n vss 5.312e-18
* device instance vsubs_dctie r0 *1 0,0
Rvsubs_dctie vsubs 0 1e+12
.ENDS sampler_dff
