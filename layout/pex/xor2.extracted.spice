* extracted by klt extract --deck gf180mcu
* parasitic model (--parasitics):
* - capacitance: net-to-ground for every net's own (non-coupled) area/perimeter, plus net-to-net for the vertical-overlap coupling `coupling` describes below -- a coupled net pair gets a direct capacitor between their two hub nodes, not just capacitors to the deck's ground/substrate net
* - coupling: vertical overlap (crossover) unconditionally -- where one net's conductor on an adjacent metal level sits directly over another *distinct* net's conductor, that overlap area is charged between the two nets instead of to ground (issue #760) -- plus lateral (same-layer, sidewall) coupling, but only for a net pair naming one of the caller's declared `--critical-net` nets (issue #976): facing-edge length within that layer's own minimum-spacing lookback is charged between the two nets, *additively* (not deducted from either net's substrate fringe term, unlike the vertical case -- a known simplification). Any same-layer pair with neither side named `--critical-net`, and fringe shielding in general, are still not modelled
* - resistance: single lumped series resistance per net, distributed as a star across that net's device terminals (issue #592) -- not a per-segment, distributed RC ladder, *unless* `--distributed-rc` names this net via `--critical-net` (issue #977, Epic #709 Phase 2b): then the net's terminals are ordered along their approximate physical spread and its total R/C is broken into a chain of per-segment resistors (segment length proportional to inter-terminal distance) with a ground capacitor at each terminal node (proportional to its adjacent segment length/2), instead of one star hub -- still an approximation (terminal position is a device-placement proxy, not true per-segment routing geometry), but a strictly finer-grained one than the single-hub star
* - frequency: quasi-static -- one frequency-independent R and C per net; no skin effect, no distributed transmission-line behavior
* - substrate tie: 1e+12 ohm to ground -- the substrate is capacitively floating in transient analysis (DC reference only); see --substrate-tie-ohms
.GLOBAL vsubs

* cell xor2
* pin a
* pin b
* pin vdd
* pin vss
* pin y
.SUBCKT xor2 a b vdd vss y
* device instance $1 r0 *1 0.8,1 nfet
X$1 \$4__t0 a__t0 vss__t0 vss__t4 nfet_03v3 L=0.28U W=0.22U AS=0.3872P
+ AD=0.3872P PS=2.64U PD=2.64U
* device instance $2 r0 *1 3.2,1 nfet
X$2 \$6__t1 b__t3 vss__t3 vss__t5 nfet_03v3 L=0.28U W=0.22U AS=0.3872P
+ AD=0.3872P PS=2.64U PD=2.64U
* device instance $3 r0 *1 5.6,1 nfet
X$3 y__t3 a__t1 \$7__t1 vss__t6 nfet_03v3 L=0.28U W=0.44U AS=0.3872P AD=0.3872P
+ PS=2.64U PD=2.64U
* device instance $4 r0 *1 8,1 nfet
X$4 \$7__t0 b__t2 vss__t1 vss__t7 nfet_03v3 L=0.28U W=0.44U AS=0.3872P
+ AD=0.3872P PS=2.64U PD=2.64U
* device instance $5 r0 *1 10.4,1 nfet
X$5 y__t2 \$4__t3 \$9__t1 vss__t8 nfet_03v3 L=0.28U W=0.44U AS=0.3872P
+ AD=0.3872P PS=2.64U PD=2.64U
* device instance $6 r0 *1 12.8,1 nfet
X$6 \$9__t0 \$6__t3 vss__t2 vss__t9 nfet_03v3 L=0.28U W=0.44U AS=0.3872P
+ AD=0.3872P PS=2.64U PD=2.64U
* device instance $7 r0 *1 17.4,1 pfet
X$7 \$4__t1 a__t2 vdd__t0 vdd__t1 pfet_03v3 L=0.28U W=0.44U AS=0.3872P
+ AD=0.3872P PS=2.64U PD=2.64U
* device instance $8 r0 *1 19.8,1 pfet
X$8 \$6__t0 b__t1 vdd__t9 vdd__t8 pfet_03v3 L=0.28U W=0.44U AS=0.3872P
+ AD=0.3872P PS=2.64U PD=2.64U
* device instance $9 r0 *1 22.2,1 pfet
X$9 \$10__t1 a__t3 vdd__t2 vdd__t3 pfet_03v3 L=0.28U W=0.88U AS=0.7744P
+ AD=0.7744P PS=3.52U PD=3.52U
* device instance $10 r0 *1 24.6,1 pfet
X$10 \$10__t0 b__t0 vdd__t7 vdd__t6 pfet_03v3 L=0.28U W=0.88U AS=0.7744P
+ AD=0.7744P PS=3.52U PD=3.52U
* device instance $11 r0 *1 27,1 pfet
X$11 y__t0 \$4__t2 \$10__t3 vdd__t5 pfet_03v3 L=0.28U W=0.88U AS=0.7744P
+ AD=0.7744P PS=3.52U PD=3.52U
* device instance $12 r0 *1 29.4,1 pfet
X$12 y__t1 \$6__t2 \$10__t2 vdd__t4 pfet_03v3 L=0.28U W=0.88U AS=0.7744P
+ AD=0.7744P PS=3.52U PD=3.52U
* device instance _10_t0 r0 *1 0,0
R_10_t0 \$10__t0 \$10 1.27725
* device instance _10_t1 r0 *1 0,0
R_10_t1 \$10__t1 \$10 3.83175
* device instance _10_t2 r0 *1 0,0
R_10_t2 \$10__t2 \$10 3.83175
* device instance _10_t3 r0 *1 0,0
R_10_t3 \$10__t3 \$10 1.27725
* device instance _10 r0 *1 0,0
C_10 \$10 vsubs 2.572597e-15
* device instance _4_t0 r0 *1 0,0
R_4_t0 \$4__t0 \$4 29.1833671687
* device instance _4_t1 r0 *1 0,0
R_4_t1 \$4__t1 \$4 7.79708283133
* device instance _4_t2 r0 *1 0,0
R_4_t2 \$4__t2 \$4 29.1833671687
* device instance _4_t3 r0 *1 0,0
R_4_t3 \$4__t3 \$4 7.79708283133
* device instance _4 r0 *1 0,0
C_4 \$4 vsubs 3.947289e-15
* device instance _6_t0 r0 *1 0,0
R_6_t0 \$6__t0 \$6 7.87931174699
* device instance _6_t1 r0 *1 0,0
R_6_t1 \$6__t1 \$6 29.491138253
* device instance _6_t2 r0 *1 0,0
R_6_t2 \$6__t2 \$6 29.491138253
* device instance _6_t3 r0 *1 0,0
R_6_t3 \$6__t3 \$6 7.87931174699
* device instance _6 r0 *1 0,0
C_6 \$6 vsubs 4.111249e-15
* device instance _7_t0 r0 *1 0,0
R_7_t0 \$7__t0 \$7 2.952
* device instance _7_t1 r0 *1 0,0
R_7_t1 \$7__t1 \$7 2.952
* device instance _7 r0 *1 0,0
C_7 \$7 vsubs 1.470177e-15
* device instance _9_t0 r0 *1 0,0
R_9_t0 \$9__t0 \$9 3.147
* device instance _9_t1 r0 *1 0,0
R_9_t1 \$9__t1 \$9 3.147
* device instance _9 r0 *1 0,0
C_9 \$9 vsubs 1.552168e-15
* device instance a_t0 r0 *1 0,0
Ra_t0 a__t0 a 44.3484704819
* device instance a_t1 r0 *1 0,0
Ra_t1 a__t1 a 24.4538295181
* device instance a_t2 r0 *1 0,0
Ra_t2 a__t2 a 24.4538295181
* device instance a_t3 r0 *1 0,0
Ra_t3 a__t3 a 44.3484704819
* device instance a r0 *1 0,0
Ca a vsubs 3.187886e-15
* device instance b_t0 r0 *1 0,0
Rb_t0 b__t0 b 44.5998560241
* device instance b_t1 r0 *1 0,0
Rb_t1 b__t1 b 24.5924439759
* device instance b_t2 r0 *1 0,0
Rb_t2 b__t2 b 24.5924439759
* device instance b_t3 r0 *1 0,0
Rb_t3 b__t3 b 44.5998560241
* device instance b r0 *1 0,0
Cb b vsubs 3.353197e-15
* device instance vdd_t0 r0 *1 0,0
Rvdd_t0 vdd__t0 vdd 1.35497727273
* device instance vdd_t1 r0 *1 0,0
Rvdd_t1 vdd__t1 vdd 1.35497727273
* device instance vdd_t2 r0 *1 0,0
Rvdd_t2 vdd__t2 vdd 0.0645227272727
* device instance vdd_t3 r0 *1 0,0
Rvdd_t3 vdd__t3 vdd 0.0645227272727
* device instance vdd_t4 r0 *1 0,0
Rvdd_t4 vdd__t4 vdd 1.87115909091
* device instance vdd_t5 r0 *1 0,0
Rvdd_t5 vdd__t5 vdd 1.22593181818
* device instance vdd_t6 r0 *1 0,0
Rvdd_t6 vdd__t6 vdd 0.580704545455
* device instance vdd_t7 r0 *1 0,0
Rvdd_t7 vdd__t7 vdd 0.580704545455
* device instance vdd_t8 r0 *1 0,0
Rvdd_t8 vdd__t8 vdd 0.70975
* device instance vdd_t9 r0 *1 0,0
Rvdd_t9 vdd__t9 vdd 0.70975
* device instance vdd r0 *1 0,0
Cvdd vdd vsubs 2.275962e-15
* device instance vss_t0 r0 *1 0,0
Rvss_t0 vss__t0 vss 1.590585
* device instance vss_t1 r0 *1 0,0
Rvss_t1 vss__t1 vss 0.39764625
* device instance vss_t2 r0 *1 0,0
Rvss_t2 vss__t2 vss 1.72313375
* device instance vss_t3 r0 *1 0,0
Rvss_t3 vss__t3 vss 0.92784125
* device instance vss_t4 r0 *1 0,0
Rvss_t4 vss__t4 vss 1.590585
* device instance vss_t5 r0 *1 0,0
Rvss_t5 vss__t5 vss 0.92784125
* device instance vss_t6 r0 *1 0,0
Rvss_t6 vss__t6 vss 0.2650975
* device instance vss_t7 r0 *1 0,0
Rvss_t7 vss__t7 vss 0.39764625
* device instance vss_t8 r0 *1 0,0
Rvss_t8 vss__t8 vss 1.06039
* device instance vss_t9 r0 *1 0,0
Rvss_t9 vss__t9 vss 1.72313375
* device instance vss r0 *1 0,0
Cvss vss vsubs 2.742148e-15
* device instance y_t0 r0 *1 0,0
Ry_t0 y__t0 y 2.59465841584
* device instance y_t1 r0 *1 0,0
Ry_t1 y__t1 y 3.29434158416
* device instance y_t2 r0 *1 0,0
Ry_t2 y__t2 y 2.24481683168
* device instance y_t3 r0 *1 0,0
Ry_t3 y__t3 y 3.64418316832
* device instance y r0 *1 0,0
Cy y vsubs 3.029218e-15
* device instance cc__10__4 r0 *1 0,0
Ccc__10__4 \$10 \$4 1.5937e-17
* device instance cc__10__6 r0 *1 0,0
Ccc__10__6 \$10 \$6 2.125e-17
* device instance cc__10_b r0 *1 0,0
Ccc__10_b \$10 b 5.312e-18
* device instance cc__10_vdd r0 *1 0,0
Ccc__10_vdd \$10 vdd 5.312e-18
* device instance cc__10_y r0 *1 0,0
Ccc__10_y \$10 y 2.125e-17
* device instance cc__4__6 r0 *1 0,0
Ccc__4__6 \$4 \$6 1.5937e-17
* device instance cc__4__7 r0 *1 0,0
Ccc__4__7 \$4 \$7 1.0625e-17
* device instance cc__4__9 r0 *1 0,0
Ccc__4__9 \$4 \$9 1.0625e-17
* device instance cc__4_a r0 *1 0,0
Ccc__4_a \$4 a 1.5937e-17
* device instance cc__4_b r0 *1 0,0
Ccc__4_b \$4 b 1.0625e-17
* device instance cc__4_vdd r0 *1 0,0
Ccc__4_vdd \$4 vdd 5.312e-18
* device instance cc__4_vss r0 *1 0,0
Ccc__4_vss \$4 vss 1.0625e-17
* device instance cc__4_y r0 *1 0,0
Ccc__4_y \$4 y 1.5937e-17
* device instance cc__6__7 r0 *1 0,0
Ccc__6__7 \$6 \$7 1.0625e-17
* device instance cc__6__9 r0 *1 0,0
Ccc__6__9 \$6 \$9 1.0625e-17
* device instance cc__6_a r0 *1 0,0
Ccc__6_a \$6 a 1.5937e-17
* device instance cc__6_b r0 *1 0,0
Ccc__6_b \$6 b 1.5937e-17
* device instance cc__6_vdd r0 *1 0,0
Ccc__6_vdd \$6 vdd 5.312e-18
* device instance cc__6_vss r0 *1 0,0
Ccc__6_vss \$6 vss 5.312e-18
* device instance cc__6_y r0 *1 0,0
Ccc__6_y \$6 y 1.5937e-17
* device instance cc__7_a r0 *1 0,0
Ccc__7_a \$7 a 1.0625e-17
* device instance cc__7_b r0 *1 0,0
Ccc__7_b \$7 b 1.0625e-17
* device instance cc__7_vss r0 *1 0,0
Ccc__7_vss \$7 vss 1.0625e-17
* device instance cc__7_y r0 *1 0,0
Ccc__7_y \$7 y 5.312e-18
* device instance cc__9_a r0 *1 0,0
Ccc__9_a \$9 a 1.0625e-17
* device instance cc__9_b r0 *1 0,0
Ccc__9_b \$9 b 1.0625e-17
* device instance cc__9_vss r0 *1 0,0
Ccc__9_vss \$9 vss 5.312e-18
* device instance cc__9_y r0 *1 0,0
Ccc__9_y \$9 y 1.0625e-17
* device instance cc_a_b r0 *1 0,0
Ccc_a_b a b 1.5937e-17
* device instance cc_a_vdd r0 *1 0,0
Ccc_a_vdd a vdd 1.5937e-17
* device instance cc_a_vss r0 *1 0,0
Ccc_a_vss a vss 1.5937e-17
* device instance cc_a_y r0 *1 0,0
Ccc_a_y a y 1.0625e-17
* device instance cc_b_vdd r0 *1 0,0
Ccc_b_vdd b vdd 2.125e-17
* device instance cc_b_vss r0 *1 0,0
Ccc_b_vss b vss 1.0625e-17
* device instance cc_b_y r0 *1 0,0
Ccc_b_y b y 1.0625e-17
* device instance cc_vdd_y r0 *1 0,0
Ccc_vdd_y vdd y 2.125e-17
* device instance cc_vss_y r0 *1 0,0
Ccc_vss_y vss y 1.0625e-17
* device instance vsubs_dctie r0 *1 0,0
Rvsubs_dctie vsubs 0 1e+12
.ENDS xor2
