* extracted by klt extract --deck gf180mcu
* parasitic model (--parasitics):
* - capacitance: net-to-ground for every net's own (non-coupled) area/perimeter, plus net-to-net for the vertical-overlap coupling `coupling` describes below -- a coupled net pair gets a direct capacitor between their two hub nodes, not just capacitors to the deck's ground/substrate net
* - coupling: vertical overlap (crossover) unconditionally -- where one net's conductor on an adjacent metal level sits directly over another *distinct* net's conductor, that overlap area is charged between the two nets instead of to ground (issue #760) -- plus lateral (same-layer, sidewall) coupling, but only for a net pair naming one of the caller's declared `--critical-net` nets (issue #976): facing-edge length within that layer's own minimum-spacing lookback is charged between the two nets, *additively* (not deducted from either net's substrate fringe term, unlike the vertical case -- a known simplification). Any same-layer pair with neither side named `--critical-net`, and fringe shielding in general, are still not modelled
* - resistance: single lumped series resistance per net, distributed as a star across that net's device terminals (issue #592) -- not a per-segment, distributed RC ladder, *unless* `--distributed-rc` names this net via `--critical-net` (issue #977, Epic #709 Phase 2b): then the net's terminals are ordered along their approximate physical spread and its total R/C is broken into a chain of per-segment resistors (segment length proportional to inter-terminal distance) with a ground capacitor at each terminal node (proportional to its adjacent segment length/2), instead of one star hub -- still an approximation (terminal position is a device-placement proxy, not true per-segment routing geometry), but a strictly finer-grained one than the single-hub star
* - frequency: quasi-static -- one frequency-independent R and C per net; no skin effect, no distributed transmission-line behavior
.GLOBAL vsubs

* cell xor2
* pin a
* pin b
* pin vdd
* pin vss
* pin vsubs
* pin y
.SUBCKT xor2 a b vdd vss vsubs y
* device instance $1 r0 *1 0.8,1 nfet
X$1 \$2__t0 a__t0 vss__t0 vsubs nfet_03v3 L=0.28U W=0.22U AS=0.3872P AD=0.3872P
+ PS=2.64U PD=2.64U
* device instance $2 r0 *1 3.2,1 nfet
X$2 \$3__t3 b__t1 vss__t3 vsubs nfet_03v3 L=0.28U W=0.22U AS=0.3872P AD=0.3872P
+ PS=2.64U PD=2.64U
* device instance $3 r0 *1 5.6,1 nfet
X$3 y__t3 a__t3 \$4__t1 vsubs nfet_03v3 L=0.28U W=0.44U AS=0.3872P AD=0.3872P
+ PS=2.64U PD=2.64U
* device instance $4 r0 *1 8,1 nfet
X$4 \$4__t0 b__t3 vss__t1 vsubs nfet_03v3 L=0.28U W=0.44U AS=0.3872P AD=0.3872P
+ PS=2.64U PD=2.64U
* device instance $5 r0 *1 10.4,1 nfet
X$5 y__t2 \$2__t1 \$6__t1 vsubs nfet_03v3 L=0.28U W=0.44U AS=0.3872P AD=0.3872P
+ PS=2.64U PD=2.64U
* device instance $6 r0 *1 12.8,1 nfet
X$6 \$6__t0 \$3__t2 vss__t2 vsubs nfet_03v3 L=0.28U W=0.44U AS=0.3872P
+ AD=0.3872P PS=2.64U PD=2.64U
* device instance $7 r0 *1 17.4,1 pfet
X$7 \$2__t2 a__t1 vdd__t0 \$11 pfet_03v3 L=0.28U W=0.44U AS=0.3872P AD=0.3872P
+ PS=2.64U PD=2.64U
* device instance $8 r0 *1 19.8,1 pfet
X$8 \$3__t1 b__t0 vdd__t3 \$11 pfet_03v3 L=0.28U W=0.44U AS=0.3872P AD=0.3872P
+ PS=2.64U PD=2.64U
* device instance $9 r0 *1 22.2,1 pfet
X$9 \$8__t3 a__t2 vdd__t1 \$11 pfet_03v3 L=0.28U W=0.88U AS=0.7744P AD=0.7744P
+ PS=3.52U PD=3.52U
* device instance $10 r0 *1 24.6,1 pfet
X$10 \$8__t2 b__t2 vdd__t2 \$11 pfet_03v3 L=0.28U W=0.88U AS=0.7744P AD=0.7744P
+ PS=3.52U PD=3.52U
* device instance $11 r0 *1 27,1 pfet
X$11 y__t0 \$2__t3 \$8__t1 \$11 pfet_03v3 L=0.28U W=0.88U AS=0.7744P AD=0.7744P
+ PS=3.52U PD=3.52U
* device instance $12 r0 *1 29.4,1 pfet
X$12 y__t1 \$3__t0 \$8__t0 \$11 pfet_03v3 L=0.28U W=0.88U AS=0.7744P AD=0.7744P
+ PS=3.52U PD=3.52U
* device instance _2_t0 r0 *1 0,0
R_2_t0 \$2__t0 \$2 48.3122475904
* device instance _2_t1 r0 *1 0,0
R_2_t1 \$2__t1 \$2 12.9078524096
* device instance _2_t2 r0 *1 0,0
R_2_t2 \$2__t2 \$2 12.9078524096
* device instance _2_t3 r0 *1 0,0
R_2_t3 \$2__t3 \$2 48.3122475904
* device instance _2 r0 *1 0,0
C_2 \$2 vsubs 3.947289e-15
* device instance _3_t0 r0 *1 0,0
R_3_t0 \$3__t0 \$3 48.6189927711
* device instance _3_t1 r0 *1 0,0
R_3_t1 \$3__t1 \$3 12.9898072289
* device instance _3_t2 r0 *1 0,0
R_3_t2 \$3__t2 \$3 12.9898072289
* device instance _3_t3 r0 *1 0,0
R_3_t3 \$3__t3 \$3 48.6189927711
* device instance _3 r0 *1 0,0
C_3 \$3 vsubs 4.111249e-15
* device instance _4_t0 r0 *1 0,0
R_4_t0 \$4__t0 \$4 3.4309
* device instance _4_t1 r0 *1 0,0
R_4_t1 \$4__t1 \$4 3.4309
* device instance _4 r0 *1 0,0
C_4 \$4 vsubs 1.470177e-15
* device instance _6_t0 r0 *1 0,0
R_6_t0 \$6__t0 \$6 3.62565
* device instance _6_t1 r0 *1 0,0
R_6_t1 \$6__t1 \$6 3.62565
* device instance _6 r0 *1 0,0
C_6 \$6 vsubs 1.552168e-15
* device instance _8_t0 r0 *1 0,0
R_8_t0 \$8__t0 \$8 4.6962375
* device instance _8_t1 r0 *1 0,0
R_8_t1 \$8__t1 \$8 1.5654125
* device instance _8_t2 r0 *1 0,0
R_8_t2 \$8__t2 \$8 1.5654125
* device instance _8_t3 r0 *1 0,0
R_8_t3 \$8__t3 \$8 4.6962375
* device instance _8 r0 *1 0,0
C_8 \$8 vsubs 2.572597e-15
* device instance a_t0 r0 *1 0,0
Ra_t0 a__t0 a 79.2230900602
* device instance a_t1 r0 *1 0,0
Ra_t1 a__t1 a 43.6837599398
* device instance a_t2 r0 *1 0,0
Ra_t2 a__t2 a 79.2230900602
* device instance a_t3 r0 *1 0,0
Ra_t3 a__t3 a 43.6837599398
* device instance a r0 *1 0,0
Ca a vsubs 3.187886e-15
* device instance b_t0 r0 *1 0,0
Rb_t0 b__t0 b 43.815710241
* device instance b_t1 r0 *1 0,0
Rb_t1 b__t1 b 79.462389759
* device instance b_t2 r0 *1 0,0
Rb_t2 b__t2 b 79.462389759
* device instance b_t3 r0 *1 0,0
Rb_t3 b__t3 b 43.815710241
* device instance b r0 *1 0,0
Cb b vsubs 3.353197e-15
* device instance vdd_t0 r0 *1 0,0
Rvdd_t0 vdd__t0 vdd 3.7041375
* device instance vdd_t1 r0 *1 0,0
Rvdd_t1 vdd__t1 vdd 1.2347125
* device instance vdd_t2 r0 *1 0,0
Rvdd_t2 vdd__t2 vdd 3.7041375
* device instance vdd_t3 r0 *1 0,0
Rvdd_t3 vdd__t3 vdd 1.2347125
* device instance vdd r0 *1 0,0
Cvdd vdd vsubs 2.028191e-15
* device instance vss_t0 r0 *1 0,0
Rvss_t0 vss__t0 vss 3.879
* device instance vss_t1 r0 *1 0,0
Rvss_t1 vss__t1 vss 1.293
* device instance vss_t2 r0 *1 0,0
Rvss_t2 vss__t2 vss 4.741
* device instance vss_t3 r0 *1 0,0
Rvss_t3 vss__t3 vss 2.155
* device instance vss r0 *1 0,0
Cvss vss vsubs 2.533037e-15
* device instance y_t0 r0 *1 0,0
Ry_t0 y__t0 y 3.09193490099
* device instance y_t1 r0 *1 0,0
Ry_t1 y__t1 y 3.92571509901
* device instance y_t2 r0 *1 0,0
Ry_t2 y__t2 y 2.67504480198
* device instance y_t3 r0 *1 0,0
Ry_t3 y__t3 y 4.34260519802
* device instance y r0 *1 0,0
Cy y vsubs 3.029218e-15
* device instance cc__2__3 r0 *1 0,0
Ccc__2__3 \$2 \$3 1.5937e-17
* device instance cc__2__4 r0 *1 0,0
Ccc__2__4 \$2 \$4 1.0625e-17
* device instance cc__2__6 r0 *1 0,0
Ccc__2__6 \$2 \$6 1.0625e-17
* device instance cc__2__8 r0 *1 0,0
Ccc__2__8 \$2 \$8 1.5937e-17
* device instance cc__2_a r0 *1 0,0
Ccc__2_a \$2 a 1.5937e-17
* device instance cc__2_b r0 *1 0,0
Ccc__2_b \$2 b 1.0625e-17
* device instance cc__2_vdd r0 *1 0,0
Ccc__2_vdd \$2 vdd 5.312e-18
* device instance cc__2_vss r0 *1 0,0
Ccc__2_vss \$2 vss 1.0625e-17
* device instance cc__2_y r0 *1 0,0
Ccc__2_y \$2 y 1.5937e-17
* device instance cc__3__4 r0 *1 0,0
Ccc__3__4 \$3 \$4 1.0625e-17
* device instance cc__3__6 r0 *1 0,0
Ccc__3__6 \$3 \$6 1.0625e-17
* device instance cc__3__8 r0 *1 0,0
Ccc__3__8 \$3 \$8 2.125e-17
* device instance cc__3_a r0 *1 0,0
Ccc__3_a \$3 a 1.5937e-17
* device instance cc__3_b r0 *1 0,0
Ccc__3_b \$3 b 1.5937e-17
* device instance cc__3_vdd r0 *1 0,0
Ccc__3_vdd \$3 vdd 5.312e-18
* device instance cc__3_vss r0 *1 0,0
Ccc__3_vss \$3 vss 5.312e-18
* device instance cc__3_y r0 *1 0,0
Ccc__3_y \$3 y 1.5937e-17
* device instance cc__4_a r0 *1 0,0
Ccc__4_a \$4 a 1.0625e-17
* device instance cc__4_b r0 *1 0,0
Ccc__4_b \$4 b 1.0625e-17
* device instance cc__4_vss r0 *1 0,0
Ccc__4_vss \$4 vss 1.0625e-17
* device instance cc__4_y r0 *1 0,0
Ccc__4_y \$4 y 5.312e-18
* device instance cc__6_a r0 *1 0,0
Ccc__6_a \$6 a 1.0625e-17
* device instance cc__6_b r0 *1 0,0
Ccc__6_b \$6 b 1.0625e-17
* device instance cc__6_vss r0 *1 0,0
Ccc__6_vss \$6 vss 5.312e-18
* device instance cc__6_y r0 *1 0,0
Ccc__6_y \$6 y 1.0625e-17
* device instance cc__8_b r0 *1 0,0
Ccc__8_b \$8 b 5.312e-18
* device instance cc__8_vdd r0 *1 0,0
Ccc__8_vdd \$8 vdd 5.312e-18
* device instance cc__8_y r0 *1 0,0
Ccc__8_y \$8 y 2.125e-17
* device instance cc_a_b r0 *1 0,0
Ccc_a_b a b 1.5937e-17
* device instance cc_a_vdd r0 *1 0,0
Ccc_a_vdd a vdd 1.5937e-17
* device instance cc_a_vss r0 *1 0,0
Ccc_a_vss a vss 1.5937e-17
* device instance cc_a_y r0 *1 0,0
Ccc_a_y a y 1.0625e-17
* device instance cc_b_vdd r0 *1 0,0
Ccc_b_vdd b vdd 2.125e-17
* device instance cc_b_vss r0 *1 0,0
Ccc_b_vss b vss 1.0625e-17
* device instance cc_b_y r0 *1 0,0
Ccc_b_y b y 1.0625e-17
* device instance cc_vdd_y r0 *1 0,0
Ccc_vdd_y vdd y 2.125e-17
* device instance cc_vss_y r0 *1 0,0
Ccc_vss_y vss y 1.0625e-17
* device instance vsubs_dctie r0 *1 0,0
Rvsubs_dctie vsubs 0 1e+12
.ENDS xor2
