* GENERATED by layout/pex/build.py -- do not edit by hand.
* Post-layout, FULL-CHIP-DELTA-annotated drop-in replacement for design/sampler_core.spice,
* extending sampler_core.routed.extracted.spice with the two-net inter-
* region delta DR-0025 authorises: klt extract --parasitics --pdk gf180mcuD
* over the composed, routed layout/floorplan/trng_floorplan.gds, less what
* ro_ring11(_ring2).routed.extracted.spice and
* combiner_sampler.routed.extracted.spice already carry for that same
* physical net (see layout/pex/reports/fullchip_parasitics.json and this
* file's own module docstring, "Full-chip (inter-region) delta
* composition", for what this captures and what it does not -- DR-0025's
* own stated coverage hole).
* Regenerate with: python3 layout/pex/build.py --fullchip-extract && python3 layout/pex/build.py
.include "ro_ring11.routed.extracted.spice"
.include "ro_ring11_ring2.routed.extracted.spice"
.include "combiner_sampler.routed.extracted.spice"

.subckt ro_ring11_routed_extracted en ro vddr vss vsubs
xcore n1 n2 n3 n4 n5 n6 n7 n8 n9 n10 ro en vddr vss vsubs ro_ring11
.ends

.subckt ro_ring11_ring2_routed_extracted en ro vddr vss vsubs
xcore ro n1 n2 n3 n4 n5 n6 n7 n8 n9 n10 en vddr vss vsubs ro_ring11_ring2
.ends

.subckt combiner_sampler_routed_extracted rn1 rn2 vdd vss clk rst_n raw_bit raw_valid ring_bit1 ring_bit2 vsubs
xcore rn1 rn2 ro1 ro2 clk vdd xo raw_bit raw_valid ring_bit1 ring_bit2 rst_n vss vsubs combiner_sampler
.ends

.subckt sampler_core_fullchip_extracted en1 en2 vddr1 vddr2 vdd vss clk rst_n raw_bit raw_valid ring_bit1 ring_bit2 vsubs
xr1 en1 dro1 vddr1 vss vsubs ro_ring11_routed_extracted
xr2 en2 dro2 vddr2 vss vsubs ro_ring11_ring2_routed_extracted
cdelta1a dro1 vsubs 4.258439e-15
rdelta1 dro1 rn1 57.548200
cdelta1b rn1 vsubs 4.258439e-15
cdelta2a dro2 vsubs 1.594116e-15
rdelta2 dro2 rn2 30.223600
cdelta2b rn2 vsubs 1.594116e-15
xcs rn1 rn2 vdd vss clk rst_n raw_bit raw_valid ring_bit1 ring_bit2 vsubs combiner_sampler_routed_extracted
cload_raw_bit raw_bit vsubs 8.800307e-14
cload_raw_valid raw_valid vsubs 9.240300e-14
cload_ring_bit1 ring_bit1 vsubs 2.795017e-14
cload_ring_bit2 ring_bit2 vsubs 2.894170e-14
.ends
