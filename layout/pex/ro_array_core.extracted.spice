* GENERATED by layout/pex/build.py -- do not edit by hand.
* Post-layout, device-level-parasitic-annotated drop-in replacement for
* design/ro_array_core.spice, composed from `klt extract --parasitics --pdk gf180mcuD` runs
* over this design's individually drawn, DRC-clean, LVS-matching leaf
* cells (layout/cells/), using EXACTLY the instance-level topology
* design/ro_array_core.spice itself declares -- see this file's own module docstring
* (layout/pex/build.py) for what this captures and what it does not.
* Regenerate with: python3 layout/pex/build.py
.include "ro_stage.extracted.spice"
.include "ro_nand2.extracted.spice"
.include "ro_stage_ring2.extracted.spice"
.include "ro_nand2_ring2.extracted.spice"
.include "ro_buf.extracted.spice"
.include "xor2.extracted.spice"

.subckt ro_ring11_extracted en ro vddr vss vsubs
xg ro en vddr vss vsubs n1 ro_nand2
x1 n1 vddr vss vsubs n2 ro_stage
x2 n2 vddr vss vsubs n3 ro_stage
x3 n3 vddr vss vsubs n4 ro_stage
x4 n4 vddr vss vsubs n5 ro_stage
x5 n5 vddr vss vsubs n6 ro_stage
x6 n6 vddr vss vsubs n7 ro_stage
x7 n7 vddr vss vsubs n8 ro_stage
x8 n8 vddr vss vsubs n9 ro_stage
x9 n9 vddr vss vsubs n10 ro_stage
x10 n10 vddr vss vsubs ro ro_stage
.ends

.subckt ro_ring11_ring2_extracted en ro vddr vss vsubs
xg ro en vddr vss vsubs n1 ro_nand2_ring2
x1 n1 vddr vss vsubs n2 ro_stage_ring2
x2 n2 vddr vss vsubs n3 ro_stage_ring2
x3 n3 vddr vss vsubs n4 ro_stage_ring2
x4 n4 vddr vss vsubs n5 ro_stage_ring2
x5 n5 vddr vss vsubs n6 ro_stage_ring2
x6 n6 vddr vss vsubs n7 ro_stage_ring2
x7 n7 vddr vss vsubs n8 ro_stage_ring2
x8 n8 vddr vss vsubs n9 ro_stage_ring2
x9 n9 vddr vss vsubs n10 ro_stage_ring2
x10 n10 vddr vss vsubs ro ro_stage_ring2
.ends

.subckt ro_array_core_extracted en1 en2 vddr1 vddr2 vdd vss xo ro1 ro2 vsubs
xr1 en1 rn1 vddr1 vss vsubs ro_ring11_extracted
xr2 en2 rn2 vddr2 vss vsubs ro_ring11_ring2_extracted
xb1 rn1 vdd vss vsubs ro1 ro_buf
xb2 rn2 vdd vss vsubs ro2 ro_buf
xa1 ro1 ro2 vdd vss vsubs xo xor2
.ends
