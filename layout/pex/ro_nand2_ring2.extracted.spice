* extracted by klt extract --deck gf180mcu
* parasitic model (--parasitics):
* - capacitance: net-to-ground for every net's own (non-coupled) area/perimeter, plus net-to-net for the vertical-overlap coupling `coupling` describes below -- a coupled net pair gets a direct capacitor between their two hub nodes, not just capacitors to the deck's ground/substrate net
* - coupling: vertical overlap (crossover) unconditionally -- where one net's conductor on an adjacent metal level sits directly over another *distinct* net's conductor, that overlap area is charged between the two nets instead of to ground (issue #760) -- plus lateral (same-layer, sidewall) coupling, but only for a net pair naming one of the caller's declared `--critical-net` nets (issue #976): facing-edge length within that layer's own minimum-spacing lookback is charged between the two nets, *additively* (not deducted from either net's substrate fringe term, unlike the vertical case -- a known simplification). Any same-layer pair with neither side named `--critical-net`, and fringe shielding in general, are still not modelled
* - resistance: single lumped series resistance per net, distributed as a star across that net's device terminals (issue #592) -- not a per-segment, distributed RC ladder, *unless* `--distributed-rc` names this net via `--critical-net` (issue #977, Epic #709 Phase 2b): then the net's terminals are ordered along their approximate physical spread and its total R/C is broken into a chain of per-segment resistors (segment length proportional to inter-terminal distance) with a ground capacitor at each terminal node (proportional to its adjacent segment length/2), instead of one star hub -- still an approximation (terminal position is a device-placement proxy, not true per-segment routing geometry), but a strictly finer-grained one than the single-hub star
* - frequency: quasi-static -- one frequency-independent R and C per net; no skin effect, no distributed transmission-line behavior
.GLOBAL vsubs

* cell ro_nand2_ring2
* pin a
* pin en
* pin vddr
* pin vss
* pin vsubs
* pin y
.SUBCKT ro_nand2_ring2 a en vddr vss vsubs y
* device instance $1 r0 *1 3.86,0.22 nfet
X$1 vss__t0 vddr__t0 \$8 vsubs nfet_03v3 L=2U W=0.24U AS=0.176P AD=0.308P
+ PS=1.24U PD=2.28U
* device instance $2 r0 *1 0.84,0.22 nfet
X$2 \$7 a__t0 y__t0 vsubs nfet_03v3 L=0.28U W=0.44U AS=0.308P AD=0.176P
+ PS=2.28U PD=1.24U
* device instance $3 r0 *1 1.92,0.22 nfet
X$3 \$8 en__t0 \$7 vsubs nfet_03v3 L=0.28U W=0.44U AS=0.176P AD=0.176P PS=1.24U
+ PD=1.24U
* device instance $4 r0 *1 -1.1,1.86 pfet
X$4 \$5__t1 vss__t1 vddr__t1 \$9 pfet_03v3 L=2U W=0.24U AS=0.308P AD=0.176P
+ PS=2.28U PD=1.24U
* device instance $5 r0 *1 0.84,1.86 pfet
X$5 y__t1 a__t1 \$5__t2 \$9 pfet_03v3 L=0.28U W=0.44U AS=0.176P AD=0.176P
+ PS=1.24U PD=1.24U
* device instance $6 r0 *1 1.92,1.86 pfet
X$6 \$5__t0 en__t1 y__t2 \$9 pfet_03v3 L=0.28U W=0.44U AS=0.176P AD=0.352P
+ PS=1.24U PD=2.48U
* device instance _5_t0 r0 *1 0,0
R_5_t0 \$5__t0 \$5 0.450297379032
* device instance _5_t1 r0 *1 0,0
R_5_t1 \$5__t1 \$5 0.54475
* device instance _5_t2 r0 *1 0,0
R_5_t2 \$5__t2 \$5 0.0944526209677
* device instance _5 r0 *1 0,0
C_5 \$5 vsubs 3.26413e-16
* device instance a_t0 r0 *1 0,0
Ra_t0 a__t0 a 40.14155
* device instance a_t1 r0 *1 0,0
Ra_t1 a__t1 a 40.14155
* device instance a r0 *1 0,0
Ca a vsubs 4.47462e-16
* device instance en_t0 r0 *1 0,0
Ren_t0 en__t0 en 40.2386
* device instance en_t1 r0 *1 0,0
Ren_t1 en__t1 en 40.2386
* device instance en r0 *1 0,0
Cen en vsubs 4.38142e-16
* device instance vddr_t0 r0 *1 0,0
Rvddr_t0 vddr__t0 vddr 39.24165
* device instance vddr_t1 r0 *1 0,0
Rvddr_t1 vddr__t1 vddr 39.24165
* device instance vddr r0 *1 0,0
Cvddr vddr vsubs 1.605432e-15
* device instance vss_t0 r0 *1 0,0
Rvss_t0 vss__t0 vss 96.0338
* device instance vss_t1 r0 *1 0,0
Rvss_t1 vss__t1 vss 96.0338
* device instance vss r0 *1 0,0
Cvss vss vsubs 1.368552e-15
* device instance y_t0 r0 *1 0,0
Ry_t0 y__t0 y 0.373404977522
* device instance y_t1 r0 *1 0,0
Ry_t1 y__t1 y 0.212335722136
* device instance y_t2 r0 *1 0,0
Ry_t2 y__t2 y 0.293259300341
* device instance y r0 *1 0,0
Cy y vsubs 2.81094e-16
* device instance vsubs_dctie r0 *1 0,0
Rvsubs_dctie vsubs 0 1e+12
.ENDS ro_nand2_ring2
