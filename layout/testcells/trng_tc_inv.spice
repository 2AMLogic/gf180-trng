* trng_tc_inv -- LVS reference (schematic-side) netlist.
*
* Hand-written, NOT a copy of `klt extract` output: an LVS run whose
* reference is the extractor's own output proves nothing. This is what the
* inverter is *supposed* to be, written independently, and `klt lvs` is
* asked to agree that the drawn geometry implements it.
*
* Bulk terminals: every cell, ring and block draws an Nwell tap tied to
* `VDD` and a substrate tap tied to `VSS` (layout/testcells/gdsii.py's
* `add_taps`; klt >= 0.8.0's `comp.tap_distance.*` requires them), so the
* extractor reports every PMOS bulk as `VDD` and every NMOS bulk as
* `VSS` -- the same bulk connections design/xschem/ wires. There is no
* `vsubs` pin and no floating-well net any more.

.SUBCKT trng_tc_inv A VDD VSS ZN
MN ZN A VSS VSS nfet L=0.28U W=0.8U
MP ZN A VDD VDD pfet L=0.28U W=0.8U
.ENDS trng_tc_inv
