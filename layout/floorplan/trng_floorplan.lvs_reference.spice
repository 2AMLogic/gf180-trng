* trng_floorplan -- LVS reference (composed) netlist.
*
* Generated by design/floorplan_netlist.py -- do not hand-edit.
* Phase 1 of issue #219's own two-phase decomposition (issue #221):
* this file wires the four regions' own already-committed reference
* subcircuits together per INTER_REGION_NETS, declared as reviewable
* Python data in that module. It does NOT correspond to any drawn
* geometry yet -- the physical routing, the klt extract --top
* trng_floorplan pin-count change, and running klt lvs against this
* file are phase 2's work (a separate, follow-up issue), not done here.
*
* vddd/vss both wire into digital's own X-card too, since gf180-
* trng#224 promoted them to real .SUBCKT trng_top pins on digital's
* own committed reference (layout/digital/trng_top.lvs_reference.
* spice) -- see design/floorplan_netlist.py's own module docstring.
*
* Each region's own reference is pulled in by .INCLUDE rather than
* copied a second time (digital's own reference alone is ~8700
* lines) -- paths below are relative to this file's own directory.
.INCLUDE ../rings/ro_ring11/ro_ring11.spice
.INCLUDE ../rings/ro_ring11_ring2/ro_ring11_ring2.spice
.INCLUDE ../blocks/combiner_sampler/combiner_sampler.spice
.INCLUDE ../digital/trng_top.lvs_reference.spice

.SUBCKT trng_floorplan clk en1 en2 ht_alarm reg_addr[0] reg_addr[1] reg_rdata[0] reg_rdata[10] reg_rdata[11] reg_rdata[12] reg_rdata[13] reg_rdata[14] reg_rdata[15] reg_rdata[16] reg_rdata[17] reg_rdata[18] reg_rdata[19] reg_rdata[1] reg_rdata[20] reg_rdata[21] reg_rdata[22] reg_rdata[23] reg_rdata[24] reg_rdata[25] reg_rdata[26] reg_rdata[27] reg_rdata[28] reg_rdata[29] reg_rdata[2] reg_rdata[30] reg_rdata[31] reg_rdata[3] reg_rdata[4] reg_rdata[5] reg_rdata[6] reg_rdata[7] reg_rdata[8] reg_rdata[9] reg_sel reg_wdata[0] reg_wdata[10] reg_wdata[11] reg_wdata[12] reg_wdata[13] reg_wdata[14] reg_wdata[15] reg_wdata[16] reg_wdata[17] reg_wdata[18] reg_wdata[19] reg_wdata[1] reg_wdata[20] reg_wdata[21] reg_wdata[22] reg_wdata[23] reg_wdata[24] reg_wdata[25] reg_wdata[26] reg_wdata[27] reg_wdata[28] reg_wdata[29] reg_wdata[2] reg_wdata[30] reg_wdata[31] reg_wdata[3] reg_wdata[4] reg_wdata[5] reg_wdata[6] reg_wdata[7] reg_wdata[8] reg_wdata[9] reg_write rst_n str_data[0] str_data[10] str_data[11] str_data[12] str_data[13] str_data[14] str_data[15] str_data[16] str_data[17] str_data[18] str_data[19] str_data[1] str_data[20] str_data[21] str_data[22] str_data[23] str_data[24] str_data[25] str_data[26] str_data[27] str_data[28] str_data[29] str_data[2] str_data[30] str_data[31] str_data[3] str_data[4] str_data[5] str_data[6] str_data[7] str_data[8] str_data[9] str_ready str_valid vdd vddd vddr1 vddr2 vss
X_RING1 en1 ro1 vddr1 vss vsubs ro_ring11
X_RING2 en2 ro2 vddr2 vss vsubs ro_ring11_ring2
X_COMBINER_SAMPLER ro1 ro2 clk rst_n vdd vss raw_bit raw_valid ring_bit1 ring_bit2 vsubs combiner_sampler
X_DIGITAL clk ht_alarm raw_bit raw_valid reg_addr[0] reg_addr[1] reg_rdata[0] reg_rdata[10] reg_rdata[11] reg_rdata[12] reg_rdata[13] reg_rdata[14] reg_rdata[15] reg_rdata[16] reg_rdata[17] reg_rdata[18] reg_rdata[19] reg_rdata[1] reg_rdata[20] reg_rdata[21] reg_rdata[22] reg_rdata[23] reg_rdata[24] reg_rdata[25] reg_rdata[26] reg_rdata[27] reg_rdata[28] reg_rdata[29] reg_rdata[2] reg_rdata[30] reg_rdata[31] reg_rdata[3] reg_rdata[4] reg_rdata[5] reg_rdata[6] reg_rdata[7] reg_rdata[8] reg_rdata[9] reg_sel reg_wdata[0] reg_wdata[10] reg_wdata[11] reg_wdata[12] reg_wdata[13] reg_wdata[14] reg_wdata[15] reg_wdata[16] reg_wdata[17] reg_wdata[18] reg_wdata[19] reg_wdata[1] reg_wdata[20] reg_wdata[21] reg_wdata[22] reg_wdata[23] reg_wdata[24] reg_wdata[25] reg_wdata[26] reg_wdata[27] reg_wdata[28] reg_wdata[29] reg_wdata[2] reg_wdata[30] reg_wdata[31] reg_wdata[3] reg_wdata[4] reg_wdata[5] reg_wdata[6] reg_wdata[7] reg_wdata[8] reg_wdata[9] reg_write ring_bit1 ring_bit2 rst_n str_data[0] str_data[10] str_data[11] str_data[12] str_data[13] str_data[14] str_data[15] str_data[16] str_data[17] str_data[18] str_data[19] str_data[1] str_data[20] str_data[21] str_data[22] str_data[23] str_data[24] str_data[25] str_data[26] str_data[27] str_data[28] str_data[29] str_data[2] str_data[30] str_data[31] str_data[3] str_data[4] str_data[5] str_data[6] str_data[7] str_data[8] str_data[9] str_ready str_valid vddd vss trng_top
.ENDS trng_floorplan
