* extracted by klt extract --deck gf180mcu
* parasitic model (--parasitics):
* - capacitance: net-to-ground for every net's own (non-coupled) area/perimeter, plus net-to-net for the vertical-overlap coupling `coupling` describes below -- a coupled net pair gets a direct capacitor between their two hub nodes, not just capacitors to the deck's ground/substrate net
* - coupling: vertical overlap (crossover) unconditionally -- where one net's conductor on an adjacent metal level sits directly over another *distinct* net's conductor, that overlap area is charged between the two nets instead of to ground (issue #760) -- plus lateral (same-layer, sidewall) coupling, but only for a net pair naming one of the caller's declared `--critical-net` nets (issue #976): facing-edge length within that layer's own minimum-spacing lookback is charged between the two nets, *additively* (not deducted from either net's substrate fringe term, unlike the vertical case -- a known simplification). Any same-layer pair with neither side named `--critical-net`, and fringe shielding in general, are still not modelled
* - resistance: single lumped series resistance per net, distributed as a star across that net's device terminals (issue #592) -- not a per-segment, distributed RC ladder, *unless* `--distributed-rc` names this net via `--critical-net` (issue #977, Epic #709 Phase 2b): then the net's terminals are ordered along their approximate physical spread and its total R/C is broken into a chain of per-segment resistors (segment length proportional to inter-terminal distance) with a ground capacitor at each terminal node (proportional to its adjacent segment length/2), instead of one star hub -- still an approximation (terminal position is a device-placement proxy, not true per-segment routing geometry), but a strictly finer-grained one than the single-hub star
* - frequency: quasi-static -- one frequency-independent R and C per net; no skin effect, no distributed transmission-line behavior
* - substrate tie: 1e+12 ohm to ground -- the substrate is capacitively floating in transient analysis (DC reference only); see --substrate-tie-ohms
.GLOBAL vsubs

* cell combiner_sampler
* pin a
* pin a
* pin a,d,y
* pin b,d,y
* pin clk
* pin d,vdd
* pin d,y
* pin q
* pin q
* pin q
* pin q
* pin rst_n
* pin vss
.SUBCKT combiner_sampler a a$1 a|d|y b|d|y clk d|vdd d|y q q$1 q$2 q$3 rst_n vss
* device instance $1 r0 *1 0.84,0.22 nfet
X$1 vss__t0 a__t0 a|d|y__t0 vss__t26 nfet_03v3 L=0.28U W=0.22U AS=0.308P
+ AD=0.308P PS=2.28U PD=2.28U
* device instance $2 r0 *1 10.51,0.22 nfet
X$2 vss__t25 a__t12 b|d|y__t7 vss__t27 nfet_03v3 L=0.28U W=0.22U AS=0.308P
+ AD=0.308P PS=2.28U PD=2.28U
* device instance $3 r0 *1 24.66,1 nfet
X$3 d|y__t3 a|d|y__t2 \$7__t1 vss__t28 nfet_03v3 L=0.28U W=0.44U AS=0.3872P
+ AD=0.3872P PS=2.64U PD=2.64U
* device instance $4 r0 *1 27.06,1 nfet
X$4 \$7__t0 b|d|y__t3 vss__t2 vss__t29 nfet_03v3 L=0.28U W=0.44U AS=0.3872P
+ AD=0.3872P PS=2.64U PD=2.64U
* device instance $5 r0 *1 29.46,1 nfet
X$5 d|y__t2 \$5__t3 \$9__t1 vss__t30 nfet_03v3 L=0.28U W=0.44U AS=0.3872P
+ AD=0.3872P PS=2.64U PD=2.64U
* device instance $6 r0 *1 31.86,1 nfet
X$6 \$9__t0 \$6__t1 vss__t7 vss__t31 nfet_03v3 L=0.28U W=0.44U AS=0.3872P
+ AD=0.3872P PS=2.64U PD=2.64U
* device instance $7 r0 *1 73.55,1 nfet
X$7 \$46__t4 \$12__t3 \$17__t1 vss__t32 nfet_03v3 L=0.28U W=0.44U AS=0.3872P
+ AD=0.3872P PS=2.64U PD=2.64U
* device instance $8 r0 *1 75.95,1 nfet
X$8 \$17__t0 rst_n__t11 vss__t6 vss__t33 nfet_03v3 L=0.28U W=0.44U AS=0.3872P
+ AD=0.3872P PS=2.64U PD=2.64U
* device instance $9 r0 *1 78.35,1 nfet
X$9 \$16__t3 q__t2 \$18__t1 vss__t34 nfet_03v3 L=0.28U W=0.44U AS=0.3872P
+ AD=0.3872P PS=2.64U PD=2.64U
* device instance $10 r0 *1 80.75,1 nfet
X$10 \$18__t0 rst_n__t14 vss__t10 vss__t35 nfet_03v3 L=0.28U W=0.44U AS=0.3872P
+ AD=0.3872P PS=2.64U PD=2.64U
* device instance $11 r0 *1 134.44,1 nfet
X$11 \$48__t4 \$20__t3 \$25__t1 vss__t36 nfet_03v3 L=0.28U W=0.44U AS=0.3872P
+ AD=0.3872P PS=2.64U PD=2.64U
* device instance $12 r0 *1 136.84,1 nfet
X$12 \$25__t0 rst_n__t13 vss__t9 vss__t37 nfet_03v3 L=0.28U W=0.44U AS=0.3872P
+ AD=0.3872P PS=2.64U PD=2.64U
* device instance $13 r0 *1 139.24,1 nfet
X$13 \$24__t3 q__t22 \$26__t1 vss__t38 nfet_03v3 L=0.28U W=0.44U AS=0.3872P
+ AD=0.3872P PS=2.64U PD=2.64U
* device instance $14 r0 *1 141.64,1 nfet
X$14 \$26__t0 rst_n__t12 vss__t8 vss__t39 nfet_03v3 L=0.28U W=0.44U AS=0.3872P
+ AD=0.3872P PS=2.64U PD=2.64U
* device instance $15 r0 *1 195.33,1 nfet
X$15 \$49__t4 \$28__t3 \$33__t1 vss__t40 nfet_03v3 L=0.28U W=0.44U AS=0.3872P
+ AD=0.3872P PS=2.64U PD=2.64U
* device instance $16 r0 *1 197.73,1 nfet
X$16 \$33__t0 rst_n__t15 vss__t11 vss__t41 nfet_03v3 L=0.28U W=0.44U AS=0.3872P
+ AD=0.3872P PS=2.64U PD=2.64U
* device instance $17 r0 *1 200.13,1 nfet
X$17 \$32__t3 q__t23 \$34__t1 vss__t42 nfet_03v3 L=0.28U W=0.44U AS=0.3872P
+ AD=0.3872P PS=2.64U PD=2.64U
* device instance $18 r0 *1 202.53,1 nfet
X$18 \$34__t0 rst_n__t10 vss__t5 vss__t43 nfet_03v3 L=0.28U W=0.44U AS=0.3872P
+ AD=0.3872P PS=2.64U PD=2.64U
* device instance $19 r0 *1 256.22,1 nfet
X$19 \$50__t4 \$36__t3 \$41__t1 vss__t44 nfet_03v3 L=0.28U W=0.44U AS=0.3872P
+ AD=0.3872P PS=2.64U PD=2.64U
* device instance $20 r0 *1 258.62,1 nfet
X$20 \$41__t0 rst_n__t9 vss__t4 vss__t45 nfet_03v3 L=0.28U W=0.44U AS=0.3872P
+ AD=0.3872P PS=2.64U PD=2.64U
* device instance $21 r0 *1 261.02,1 nfet
X$21 \$40__t3 q__t24 \$42__t1 vss__t46 nfet_03v3 L=0.28U W=0.44U AS=0.3872P
+ AD=0.3872P PS=2.64U PD=2.64U
* device instance $22 r0 *1 263.42,1 nfet
X$22 \$42__t0 rst_n__t8 vss__t3 vss__t47 nfet_03v3 L=0.28U W=0.44U AS=0.3872P
+ AD=0.3872P PS=2.64U PD=2.64U
* device instance $23 r0 *1 19.86,1 nfet
X$23 \$5__t1 a|d|y__t1 vss__t1 vss__t48 nfet_03v3 L=0.28U W=0.22U AS=0.3872P
+ AD=0.3872P PS=2.64U PD=2.64U
* device instance $24 r0 *1 22.26,1 nfet
X$24 \$6__t2 b|d|y__t5 vss__t17 vss__t49 nfet_03v3 L=0.28U W=0.22U AS=0.3872P
+ AD=0.3872P PS=2.64U PD=2.64U
* device instance $25 r0 *1 56.75,1 nfet
X$25 \$11__t3 clk__t18 vss__t18 vss__t50 nfet_03v3 L=0.28U W=0.22U AS=0.3872P
+ AD=0.3872P PS=2.64U PD=2.64U
* device instance $26 r0 *1 59.15,1 nfet
X$26 d|y__t4 \$11__t4 \$12__t4 vss__t51 nfet_03v3 L=0.28U W=0.22U AS=0.3872P
+ AD=0.3872P PS=2.64U PD=2.64U
* device instance $27 r0 *1 61.55,1 nfet
X$27 \$13__t2 \$46__t6 vss__t19 vss__t52 nfet_03v3 L=0.28U W=0.22U AS=0.3872P
+ AD=0.3872P PS=2.64U PD=2.64U
* device instance $28 r0 *1 63.95,1 nfet
X$28 \$13__t3 clk__t19 \$12__t5 vss__t53 nfet_03v3 L=0.28U W=0.22U AS=0.3872P
+ AD=0.3872P PS=2.64U PD=2.64U
* device instance $29 r0 *1 66.35,1 nfet
X$29 \$46__t5 clk__t20 \$14__t4 vss__t54 nfet_03v3 L=0.28U W=0.22U AS=0.3872P
+ AD=0.3872P PS=2.64U PD=2.64U
* device instance $30 r0 *1 68.75,1 nfet
X$30 q__t3 \$14__t3 vss__t20 vss__t55 nfet_03v3 L=0.28U W=0.22U AS=0.3872P
+ AD=0.3872P PS=2.64U PD=2.64U
* device instance $31 r0 *1 71.15,1 nfet
X$31 \$16__t4 \$11__t5 \$14__t5 vss__t56 nfet_03v3 L=0.28U W=0.22U AS=0.3872P
+ AD=0.3872P PS=2.64U PD=2.64U
* device instance $32 r0 *1 117.64,1 nfet
X$32 \$19__t3 clk__t21 vss__t21 vss__t57 nfet_03v3 L=0.28U W=0.22U AS=0.3872P
+ AD=0.3872P PS=2.64U PD=2.64U
* device instance $33 r0 *1 120.04,1 nfet
X$33 d|vdd__t83 \$19__t5 \$20__t5 vss__t58 nfet_03v3 L=0.28U W=0.22U AS=0.3872P
+ AD=0.3872P PS=2.64U PD=2.64U
* device instance $34 r0 *1 122.44,1 nfet
X$34 \$21__t2 \$48__t6 vss__t23 vss__t59 nfet_03v3 L=0.28U W=0.22U AS=0.3872P
+ AD=0.3872P PS=2.64U PD=2.64U
* device instance $35 r0 *1 124.84,1 nfet
X$35 \$21__t3 clk__t22 \$20__t4 vss__t60 nfet_03v3 L=0.28U W=0.22U AS=0.3872P
+ AD=0.3872P PS=2.64U PD=2.64U
* device instance $36 r0 *1 127.24,1 nfet
X$36 \$48__t5 clk__t23 \$22__t4 vss__t61 nfet_03v3 L=0.28U W=0.22U AS=0.3872P
+ AD=0.3872P PS=2.64U PD=2.64U
* device instance $37 r0 *1 129.64,1 nfet
X$37 q__t32 \$22__t3 vss__t24 vss__t62 nfet_03v3 L=0.28U W=0.22U AS=0.3872P
+ AD=0.3872P PS=2.64U PD=2.64U
* device instance $38 r0 *1 132.04,1 nfet
X$38 \$24__t4 \$19__t4 \$22__t5 vss__t63 nfet_03v3 L=0.28U W=0.22U AS=0.3872P
+ AD=0.3872P PS=2.64U PD=2.64U
* device instance $39 r0 *1 178.53,1 nfet
X$39 \$27__t3 clk__t17 vss__t16 vss__t64 nfet_03v3 L=0.28U W=0.22U AS=0.3872P
+ AD=0.3872P PS=2.64U PD=2.64U
* device instance $40 r0 *1 180.93,1 nfet
X$40 a|d|y__t6 \$27__t5 \$28__t5 vss__t65 nfet_03v3 L=0.28U W=0.22U AS=0.3872P
+ AD=0.3872P PS=2.64U PD=2.64U
* device instance $41 r0 *1 183.33,1 nfet
X$41 \$29__t3 \$49__t6 vss__t15 vss__t66 nfet_03v3 L=0.28U W=0.22U AS=0.3872P
+ AD=0.3872P PS=2.64U PD=2.64U
* device instance $42 r0 *1 185.73,1 nfet
X$42 \$29__t2 clk__t16 \$28__t4 vss__t67 nfet_03v3 L=0.28U W=0.22U AS=0.3872P
+ AD=0.3872P PS=2.64U PD=2.64U
* device instance $43 r0 *1 188.13,1 nfet
X$43 \$49__t5 clk__t15 \$30__t5 vss__t68 nfet_03v3 L=0.28U W=0.22U AS=0.3872P
+ AD=0.3872P PS=2.64U PD=2.64U
* device instance $44 r0 *1 190.53,1 nfet
X$44 q__t33 \$30__t3 vss__t14 vss__t69 nfet_03v3 L=0.28U W=0.22U AS=0.3872P
+ AD=0.3872P PS=2.64U PD=2.64U
* device instance $45 r0 *1 192.93,1 nfet
X$45 \$32__t4 \$27__t4 \$30__t4 vss__t70 nfet_03v3 L=0.28U W=0.22U AS=0.3872P
+ AD=0.3872P PS=2.64U PD=2.64U
* device instance $46 r0 *1 239.42,1 nfet
X$46 \$35__t3 clk__t13 vss__t13 vss__t71 nfet_03v3 L=0.28U W=0.22U AS=0.3872P
+ AD=0.3872P PS=2.64U PD=2.64U
* device instance $47 r0 *1 241.82,1 nfet
X$47 b|d|y__t4 \$35__t5 \$36__t4 vss__t72 nfet_03v3 L=0.28U W=0.22U AS=0.3872P
+ AD=0.3872P PS=2.64U PD=2.64U
* device instance $48 r0 *1 244.22,1 nfet
X$48 \$37__t3 \$50__t6 vss__t22 vss__t73 nfet_03v3 L=0.28U W=0.22U AS=0.3872P
+ AD=0.3872P PS=2.64U PD=2.64U
* device instance $49 r0 *1 246.62,1 nfet
X$49 \$37__t2 clk__t14 \$36__t5 vss__t74 nfet_03v3 L=0.28U W=0.22U AS=0.3872P
+ AD=0.3872P PS=2.64U PD=2.64U
* device instance $50 r0 *1 249.02,1 nfet
X$50 \$50__t5 clk__t12 \$38__t4 vss__t75 nfet_03v3 L=0.28U W=0.22U AS=0.3872P
+ AD=0.3872P PS=2.64U PD=2.64U
* device instance $51 r0 *1 251.42,1 nfet
X$51 q__t34 \$38__t3 vss__t12 vss__t76 nfet_03v3 L=0.28U W=0.22U AS=0.3872P
+ AD=0.3872P PS=2.64U PD=2.64U
* device instance $52 r0 *1 253.82,1 nfet
X$52 \$40__t4 \$35__t4 \$38__t5 vss__t77 nfet_03v3 L=0.28U W=0.22U AS=0.3872P
+ AD=0.3872P PS=2.64U PD=2.64U
* device instance $53 r0 *1 41.26,1 pfet
X$53 \$10__t0 a|d|y__t7 d|vdd__t0 d|vdd__t1 pfet_03v3 L=0.28U W=0.88U
+ AS=0.7744P AD=0.7744P PS=3.52U PD=3.52U
* device instance $54 r0 *1 43.66,1 pfet
X$54 \$10__t1 b|d|y__t6 d|vdd__t87 d|vdd__t84 pfet_03v3 L=0.28U W=0.88U
+ AS=0.7744P AD=0.7744P PS=3.52U PD=3.52U
* device instance $55 r0 *1 46.06,1 pfet
X$55 d|y__t0 \$5__t0 \$10__t3 d|vdd__t86 pfet_03v3 L=0.28U W=0.88U AS=0.7744P
+ AD=0.7744P PS=3.52U PD=3.52U
* device instance $56 r0 *1 48.46,1 pfet
X$56 d|y__t5 \$6__t3 \$10__t2 d|vdd__t85 pfet_03v3 L=0.28U W=0.88U AS=0.7744P
+ AD=0.7744P PS=3.52U PD=3.52U
* device instance $57 r0 *1 36.46,1 pfet
X$57 \$5__t2 a|d|y__t3 d|vdd__t2 d|vdd__t3 pfet_03v3 L=0.28U W=0.44U AS=0.3872P
+ AD=0.3872P PS=2.64U PD=2.64U
* device instance $58 r0 *1 38.86,1 pfet
X$58 \$6__t0 b|d|y__t1 d|vdd__t61 d|vdd__t20 pfet_03v3 L=0.28U W=0.44U
+ AS=0.3872P AD=0.3872P PS=2.64U PD=2.64U
* device instance $59 r0 *1 85.35,1 pfet
X$59 \$11__t2 clk__t4 d|vdd__t62 d|vdd__t21 pfet_03v3 L=0.28U W=0.44U
+ AS=0.3872P AD=0.3872P PS=2.64U PD=2.64U
* device instance $60 r0 *1 87.75,1 pfet
X$60 d|y__t1 clk__t5 \$12__t1 d|vdd__t22 pfet_03v3 L=0.28U W=0.44U AS=0.3872P
+ AD=0.3872P PS=2.64U PD=2.64U
* device instance $61 r0 *1 90.15,1 pfet
X$61 \$46__t1 \$12__t0 d|vdd__t63 d|vdd__t23 pfet_03v3 L=0.28U W=0.44U
+ AS=0.3872P AD=0.3872P PS=2.64U PD=2.64U
* device instance $62 r0 *1 92.55,1 pfet
X$62 \$46__t2 rst_n__t5 d|vdd__t71 d|vdd__t35 pfet_03v3 L=0.28U W=0.44U
+ AS=0.3872P AD=0.3872P PS=2.64U PD=2.64U
* device instance $63 r0 *1 94.95,1 pfet
X$63 \$13__t0 \$46__t0 d|vdd__t64 d|vdd__t24 pfet_03v3 L=0.28U W=0.44U
+ AS=0.3872P AD=0.3872P PS=2.64U PD=2.64U
* device instance $64 r0 *1 97.35,1 pfet
X$64 \$13__t1 \$11__t1 \$12__t2 d|vdd__t52 pfet_03v3 L=0.28U W=0.44U AS=0.3872P
+ AD=0.3872P PS=2.64U PD=2.64U
* device instance $65 r0 *1 99.75,1 pfet
X$65 \$46__t3 \$11__t0 \$14__t2 d|vdd__t51 pfet_03v3 L=0.28U W=0.44U AS=0.3872P
+ AD=0.3872P PS=2.64U PD=2.64U
* device instance $66 r0 *1 102.15,1 pfet
X$66 q__t1 \$14__t0 d|vdd__t81 d|vdd__t50 pfet_03v3 L=0.28U W=0.44U AS=0.3872P
+ AD=0.3872P PS=2.64U PD=2.64U
* device instance $67 r0 *1 104.55,1 pfet
X$67 \$16__t2 q__t0 d|vdd__t80 d|vdd__t49 pfet_03v3 L=0.28U W=0.44U AS=0.3872P
+ AD=0.3872P PS=2.64U PD=2.64U
* device instance $68 r0 *1 106.95,1 pfet
X$68 \$16__t1 rst_n__t7 d|vdd__t79 d|vdd__t48 pfet_03v3 L=0.28U W=0.44U
+ AS=0.3872P AD=0.3872P PS=2.64U PD=2.64U
* device instance $69 r0 *1 109.35,1 pfet
X$69 \$16__t0 clk__t11 \$14__t1 d|vdd__t47 pfet_03v3 L=0.28U W=0.44U AS=0.3872P
+ AD=0.3872P PS=2.64U PD=2.64U
* device instance $70 r0 *1 146.24,1 pfet
X$70 \$19__t2 clk__t2 d|vdd__t59 d|vdd__t17 pfet_03v3 L=0.28U W=0.44U
+ AS=0.3872P AD=0.3872P PS=2.64U PD=2.64U
* device instance $71 r0 *1 148.64,1 pfet
X$71 d|vdd__t82 clk__t7 \$20__t1 d|vdd__t26 pfet_03v3 L=0.28U W=0.44U
+ AS=0.3872P AD=0.3872P PS=2.64U PD=2.64U
* device instance $72 r0 *1 151.04,1 pfet
X$72 \$48__t1 \$20__t0 d|vdd__t65 d|vdd__t27 pfet_03v3 L=0.28U W=0.44U
+ AS=0.3872P AD=0.3872P PS=2.64U PD=2.64U
* device instance $73 r0 *1 153.44,1 pfet
X$73 \$48__t2 rst_n__t3 d|vdd__t66 d|vdd__t28 pfet_03v3 L=0.28U W=0.44U
+ AS=0.3872P AD=0.3872P PS=2.64U PD=2.64U
* device instance $74 r0 *1 155.84,1 pfet
X$74 \$21__t0 \$48__t0 d|vdd__t67 d|vdd__t29 pfet_03v3 L=0.28U W=0.44U
+ AS=0.3872P AD=0.3872P PS=2.64U PD=2.64U
* device instance $75 r0 *1 158.24,1 pfet
X$75 \$21__t1 \$19__t0 \$20__t2 d|vdd__t30 pfet_03v3 L=0.28U W=0.44U AS=0.3872P
+ AD=0.3872P PS=2.64U PD=2.64U
* device instance $76 r0 *1 160.64,1 pfet
X$76 \$48__t3 \$19__t1 \$22__t1 d|vdd__t31 pfet_03v3 L=0.28U W=0.44U AS=0.3872P
+ AD=0.3872P PS=2.64U PD=2.64U
* device instance $77 r0 *1 163.04,1 pfet
X$77 q__t12 \$22__t0 d|vdd__t68 d|vdd__t32 pfet_03v3 L=0.28U W=0.44U AS=0.3872P
+ AD=0.3872P PS=2.64U PD=2.64U
* device instance $78 r0 *1 165.44,1 pfet
X$78 \$24__t0 q__t02 d|vdd__t69 d|vdd__t33 pfet_03v3 L=0.28U W=0.44U AS=0.3872P
+ AD=0.3872P PS=2.64U PD=2.64U
* device instance $79 r0 *1 167.84,1 pfet
X$79 \$24__t1 rst_n__t4 d|vdd__t70 d|vdd__t34 pfet_03v3 L=0.28U W=0.44U
+ AS=0.3872P AD=0.3872P PS=2.64U PD=2.64U
* device instance $80 r0 *1 170.24,1 pfet
X$80 \$24__t2 clk__t10 \$22__t2 d|vdd__t45 pfet_03v3 L=0.28U W=0.44U AS=0.3872P
+ AD=0.3872P PS=2.64U PD=2.64U
* device instance $81 r0 *1 207.13,1 pfet
X$81 \$27__t2 clk__t8 d|vdd__t72 d|vdd__t36 pfet_03v3 L=0.28U W=0.44U
+ AS=0.3872P AD=0.3872P PS=2.64U PD=2.64U
* device instance $82 r0 *1 209.53,1 pfet
X$82 a|d|y__t5 clk__t9 \$28__t1 d|vdd__t37 pfet_03v3 L=0.28U W=0.44U AS=0.3872P
+ AD=0.3872P PS=2.64U PD=2.64U
* device instance $83 r0 *1 211.93,1 pfet
X$83 \$49__t1 \$28__t0 d|vdd__t73 d|vdd__t38 pfet_03v3 L=0.28U W=0.44U
+ AS=0.3872P AD=0.3872P PS=2.64U PD=2.64U
* device instance $84 r0 *1 214.33,1 pfet
X$84 \$49__t2 rst_n__t6 d|vdd__t74 d|vdd__t39 pfet_03v3 L=0.28U W=0.44U
+ AS=0.3872P AD=0.3872P PS=2.64U PD=2.64U
* device instance $85 r0 *1 216.73,1 pfet
X$85 \$29__t0 \$49__t0 d|vdd__t75 d|vdd__t40 pfet_03v3 L=0.28U W=0.44U
+ AS=0.3872P AD=0.3872P PS=2.64U PD=2.64U
* device instance $86 r0 *1 219.13,1 pfet
X$86 \$29__t1 \$27__t0 \$28__t2 d|vdd__t41 pfet_03v3 L=0.28U W=0.44U AS=0.3872P
+ AD=0.3872P PS=2.64U PD=2.64U
* device instance $87 r0 *1 221.53,1 pfet
X$87 \$49__t3 \$27__t1 \$30__t2 d|vdd__t42 pfet_03v3 L=0.28U W=0.44U AS=0.3872P
+ AD=0.3872P PS=2.64U PD=2.64U
* device instance $88 r0 *1 223.93,1 pfet
X$88 q__t13 \$30__t0 d|vdd__t76 d|vdd__t43 pfet_03v3 L=0.28U W=0.44U AS=0.3872P
+ AD=0.3872P PS=2.64U PD=2.64U
* device instance $89 r0 *1 226.33,1 pfet
X$89 \$32__t2 q__t03 d|vdd__t77 d|vdd__t44 pfet_03v3 L=0.28U W=0.44U AS=0.3872P
+ AD=0.3872P PS=2.64U PD=2.64U
* device instance $90 r0 *1 228.73,1 pfet
X$90 \$32__t0 rst_n__t0 d|vdd__t53 d|vdd__t8 pfet_03v3 L=0.28U W=0.44U
+ AS=0.3872P AD=0.3872P PS=2.64U PD=2.64U
* device instance $91 r0 *1 231.13,1 pfet
X$91 \$32__t1 clk__t6 \$30__t1 d|vdd__t25 pfet_03v3 L=0.28U W=0.44U AS=0.3872P
+ AD=0.3872P PS=2.64U PD=2.64U
* device instance $92 r0 *1 268.02,1 pfet
X$92 \$35__t2 clk__t0 d|vdd__t54 d|vdd__t9 pfet_03v3 L=0.28U W=0.44U AS=0.3872P
+ AD=0.3872P PS=2.64U PD=2.64U
* device instance $93 r0 *1 270.42,1 pfet
X$93 b|d|y__t2 clk__t1 \$36__t1 d|vdd__t10 pfet_03v3 L=0.28U W=0.44U AS=0.3872P
+ AD=0.3872P PS=2.64U PD=2.64U
* device instance $94 r0 *1 272.82,1 pfet
X$94 \$50__t1 \$36__t0 d|vdd__t55 d|vdd__t11 pfet_03v3 L=0.28U W=0.44U
+ AS=0.3872P AD=0.3872P PS=2.64U PD=2.64U
* device instance $95 r0 *1 275.22,1 pfet
X$95 \$50__t2 rst_n__t1 d|vdd__t56 d|vdd__t12 pfet_03v3 L=0.28U W=0.44U
+ AS=0.3872P AD=0.3872P PS=2.64U PD=2.64U
* device instance $96 r0 *1 277.62,1 pfet
X$96 \$37__t0 \$50__t0 d|vdd__t57 d|vdd__t13 pfet_03v3 L=0.28U W=0.44U
+ AS=0.3872P AD=0.3872P PS=2.64U PD=2.64U
* device instance $97 r0 *1 280.02,1 pfet
X$97 \$37__t1 \$35__t0 \$36__t2 d|vdd__t14 pfet_03v3 L=0.28U W=0.44U AS=0.3872P
+ AD=0.3872P PS=2.64U PD=2.64U
* device instance $98 r0 *1 282.42,1 pfet
X$98 \$50__t3 \$35__t1 \$38__t1 d|vdd__t15 pfet_03v3 L=0.28U W=0.44U AS=0.3872P
+ AD=0.3872P PS=2.64U PD=2.64U
* device instance $99 r0 *1 284.82,1 pfet
X$99 q__t14 \$38__t0 d|vdd__t58 d|vdd__t16 pfet_03v3 L=0.28U W=0.44U AS=0.3872P
+ AD=0.3872P PS=2.64U PD=2.64U
* device instance $100 r0 *1 287.22,1 pfet
X$100 \$40__t2 q__t04 d|vdd__t78 d|vdd__t46 pfet_03v3 L=0.28U W=0.44U
+ AS=0.3872P AD=0.3872P PS=2.64U PD=2.64U
* device instance $101 r0 *1 289.62,1 pfet
X$101 \$40__t0 rst_n__t2 d|vdd__t60 d|vdd__t18 pfet_03v3 L=0.28U W=0.44U
+ AS=0.3872P AD=0.3872P PS=2.64U PD=2.64U
* device instance $102 r0 *1 292.02,1 pfet
X$102 \$40__t1 clk__t3 \$38__t2 d|vdd__t19 pfet_03v3 L=0.28U W=0.44U AS=0.3872P
+ AD=0.3872P PS=2.64U PD=2.64U
* device instance $103 r0 *1 0.84,1.86 pfet
X$103 d|vdd__t4 a__t1 a|d|y__t4 d|vdd__t5 pfet_03v3 L=0.28U W=0.44U AS=0.308P
+ AD=0.308P PS=2.28U PD=2.28U
* device instance $104 r0 *1 10.51,1.86 pfet
X$104 d|vdd__t7 a__t02 b|d|y__t0 d|vdd__t6 pfet_03v3 L=0.28U W=0.44U AS=0.308P
+ AD=0.308P PS=2.28U PD=2.28U
* device instance _10_t0 r0 *1 0,0
R_10_t0 \$10__t0 \$10 3.83175
* device instance _10_t1 r0 *1 0,0
R_10_t1 \$10__t1 \$10 1.27725
* device instance _10_t2 r0 *1 0,0
R_10_t2 \$10__t2 \$10 3.83175
* device instance _10_t3 r0 *1 0,0
R_10_t3 \$10__t3 \$10 1.27725
* device instance _10 r0 *1 0,0
C_10 \$10 vsubs 2.559879e-15
* device instance _11_t0 r0 *1 0,0
R_11_t0 \$11__t0 \$11 33.5846001048
* device instance _11_t1 r0 *1 0,0
R_11_t1 \$11__t1 \$11 29.8356214885
* device instance _11_t2 r0 *1 0,0
R_11_t2 \$11__t2 \$11 11.0907284067
* device instance _11_t3 r0 *1 0,0
R_11_t3 \$11__t3 \$11 33.5846001048
* device instance _11_t4 r0 *1 0,0
R_11_t4 \$11__t4 \$11 29.8356214885
* device instance _11_t5 r0 *1 0,0
R_11_t5 \$11__t5 \$11 11.0907284067
* device instance _11 r0 *1 0,0
C_11 \$11 vsubs 6.540865e-15
* device instance _12_t0 r0 *1 0,0
R_12_t0 \$12__t0 \$12 12.1810604326
* device instance _12_t1 r0 *1 0,0
R_12_t1 \$12__t1 \$12 9.63892608142
* device instance _12_t2 r0 *1 0,0
R_12_t2 \$12__t2 \$12 19.807463486
* device instance _12_t3 r0 *1 0,0
R_12_t3 \$12__t3 \$12 5.40203549618
* device instance _12_t4 r0 *1 0,0
R_12_t4 \$12__t4 \$12 20.6548416031
* device instance _12_t5 r0 *1 0,0
R_12_t5 \$12__t5 \$12 15.5705729008
* device instance _12 r0 *1 0,0
C_12 \$12 vsubs 6.157637e-15
* device instance _13_t0 r0 *1 0,0
R_13_t0 \$13__t0 \$13 4.77390718563
* device instance _13_t1 r0 *1 0,0
R_13_t1 \$13__t1 \$13 5.51309281437
* device instance _13_t2 r0 *1 0,0
R_13_t2 \$13__t2 \$13 5.51309281437
* device instance _13_t3 r0 *1 0,0
R_13_t3 \$13__t3 \$13 4.77390718563
* device instance _13 r0 *1 0,0
C_13 \$13 vsubs 4.965606e-15
* device instance _14_t0 r0 *1 0,0
R_14_t0 \$14__t0 \$14 14.1887057143
* device instance _14_t1 r0 *1 0,0
R_14_t1 \$14__t1 \$14 20.61378
* device instance _14_t2 r0 *1 0,0
R_14_t2 \$14__t2 \$14 12.0470142857
* device instance _14_t3 r0 *1 0,0
R_14_t3 \$14__t3 \$14 15.6165
* device instance _14_t4 r0 *1 0,0
R_14_t4 \$14__t4 \$14 17.7581914286
* device instance _14_t5 r0 *1 0,0
R_14_t5 \$14__t5 \$14 13.4748085714
* device instance _14 r0 *1 0,0
C_14 \$14 vsubs 7.754828e-15
* device instance _16_t0 r0 *1 0,0
R_16_t0 \$16__t0 \$16 5.07751552795
* device instance _16_t1 r0 *1 0,0
R_16_t1 \$16__t1 \$16 4.28
* device instance _16_t2 r0 *1 0,0
R_16_t2 \$16__t2 \$16 3.48248447205
* device instance _16_t3 r0 *1 0,0
R_16_t3 \$16__t3 \$16 5.22372670807
* device instance _16_t4 r0 *1 0,0
R_16_t4 \$16__t4 \$16 7.61627329193
* device instance _16 r0 *1 0,0
C_16 \$16 vsubs 6.153234e-15
* device instance _17_t0 r0 *1 0,0
R_17_t0 \$17__t0 \$17 3.276
* device instance _17_t1 r0 *1 0,0
R_17_t1 \$17__t1 \$17 3.276
* device instance _17 r0 *1 0,0
C_17 \$17 vsubs 1.600958e-15
* device instance _18_t0 r0 *1 0,0
R_18_t0 \$18__t0 \$18 3.861
* device instance _18_t1 r0 *1 0,0
R_18_t1 \$18__t1 \$18 3.861
* device instance _18 r0 *1 0,0
C_18 \$18 vsubs 1.84239e-15
* device instance _19_t0 r0 *1 0,0
R_19_t0 \$19__t0 \$19 29.8356214885
* device instance _19_t1 r0 *1 0,0
R_19_t1 \$19__t1 \$19 33.5846001048
* device instance _19_t2 r0 *1 0,0
R_19_t2 \$19__t2 \$19 11.0907284067
* device instance _19_t3 r0 *1 0,0
R_19_t3 \$19__t3 \$19 33.5846001048
* device instance _19_t4 r0 *1 0,0
R_19_t4 \$19__t4 \$19 11.0907284067
* device instance _19_t5 r0 *1 0,0
R_19_t5 \$19__t5 \$19 29.8356214885
* device instance _19 r0 *1 0,0
C_19 \$19 vsubs 6.540865e-15
* device instance _20_t0 r0 *1 0,0
R_20_t0 \$20__t0 \$20 12.1810604326
* device instance _20_t1 r0 *1 0,0
R_20_t1 \$20__t1 \$20 9.63892608142
* device instance _20_t2 r0 *1 0,0
R_20_t2 \$20__t2 \$20 19.807463486
* device instance _20_t3 r0 *1 0,0
R_20_t3 \$20__t3 \$20 5.40203549618
* device instance _20_t4 r0 *1 0,0
R_20_t4 \$20__t4 \$20 15.5705729008
* device instance _20_t5 r0 *1 0,0
R_20_t5 \$20__t5 \$20 20.6548416031
* device instance _20 r0 *1 0,0
C_20 \$20 vsubs 6.157637e-15
* device instance _21_t0 r0 *1 0,0
R_21_t0 \$21__t0 \$21 4.77390718563
* device instance _21_t1 r0 *1 0,0
R_21_t1 \$21__t1 \$21 5.51309281437
* device instance _21_t2 r0 *1 0,0
R_21_t2 \$21__t2 \$21 5.51309281437
* device instance _21_t3 r0 *1 0,0
R_21_t3 \$21__t3 \$21 4.77390718563
* device instance _21 r0 *1 0,0
C_21 \$21 vsubs 4.965606e-15
* device instance _22_t0 r0 *1 0,0
R_22_t0 \$22__t0 \$22 14.1887057143
* device instance _22_t1 r0 *1 0,0
R_22_t1 \$22__t1 \$22 12.0470142857
* device instance _22_t2 r0 *1 0,0
R_22_t2 \$22__t2 \$22 20.61378
* device instance _22_t3 r0 *1 0,0
R_22_t3 \$22__t3 \$22 15.6165
* device instance _22_t4 r0 *1 0,0
R_22_t4 \$22__t4 \$22 17.7581914286
* device instance _22_t5 r0 *1 0,0
R_22_t5 \$22__t5 \$22 13.4748085714
* device instance _22 r0 *1 0,0
C_22 \$22 vsubs 7.754828e-15
* device instance _24_t0 r0 *1 0,0
R_24_t0 \$24__t0 \$24 3.48248447205
* device instance _24_t1 r0 *1 0,0
R_24_t1 \$24__t1 \$24 4.28
* device instance _24_t2 r0 *1 0,0
R_24_t2 \$24__t2 \$24 5.07751552795
* device instance _24_t3 r0 *1 0,0
R_24_t3 \$24__t3 \$24 5.22372670807
* device instance _24_t4 r0 *1 0,0
R_24_t4 \$24__t4 \$24 7.61627329193
* device instance _24 r0 *1 0,0
C_24 \$24 vsubs 6.153234e-15
* device instance _25_t0 r0 *1 0,0
R_25_t0 \$25__t0 \$25 3.276
* device instance _25_t1 r0 *1 0,0
R_25_t1 \$25__t1 \$25 3.276
* device instance _25 r0 *1 0,0
C_25 \$25 vsubs 1.600958e-15
* device instance _26_t0 r0 *1 0,0
R_26_t0 \$26__t0 \$26 3.861
* device instance _26_t1 r0 *1 0,0
R_26_t1 \$26__t1 \$26 3.861
* device instance _26 r0 *1 0,0
C_26 \$26 vsubs 1.84239e-15
* device instance _27_t0 r0 *1 0,0
R_27_t0 \$27__t0 \$27 29.8356214885
* device instance _27_t1 r0 *1 0,0
R_27_t1 \$27__t1 \$27 33.5846001048
* device instance _27_t2 r0 *1 0,0
R_27_t2 \$27__t2 \$27 11.0907284067
* device instance _27_t3 r0 *1 0,0
R_27_t3 \$27__t3 \$27 33.5846001048
* device instance _27_t4 r0 *1 0,0
R_27_t4 \$27__t4 \$27 11.0907284067
* device instance _27_t5 r0 *1 0,0
R_27_t5 \$27__t5 \$27 29.8356214885
* device instance _27 r0 *1 0,0
C_27 \$27 vsubs 6.540865e-15
* device instance _28_t0 r0 *1 0,0
R_28_t0 \$28__t0 \$28 12.1810604326
* device instance _28_t1 r0 *1 0,0
R_28_t1 \$28__t1 \$28 9.63892608142
* device instance _28_t2 r0 *1 0,0
R_28_t2 \$28__t2 \$28 19.807463486
* device instance _28_t3 r0 *1 0,0
R_28_t3 \$28__t3 \$28 5.40203549618
* device instance _28_t4 r0 *1 0,0
R_28_t4 \$28__t4 \$28 15.5705729008
* device instance _28_t5 r0 *1 0,0
R_28_t5 \$28__t5 \$28 20.6548416031
* device instance _28 r0 *1 0,0
C_28 \$28 vsubs 6.157637e-15
* device instance _29_t0 r0 *1 0,0
R_29_t0 \$29__t0 \$29 4.77390718563
* device instance _29_t1 r0 *1 0,0
R_29_t1 \$29__t1 \$29 5.51309281437
* device instance _29_t2 r0 *1 0,0
R_29_t2 \$29__t2 \$29 4.77390718563
* device instance _29_t3 r0 *1 0,0
R_29_t3 \$29__t3 \$29 5.51309281437
* device instance _29 r0 *1 0,0
C_29 \$29 vsubs 4.965606e-15
* device instance _30_t0 r0 *1 0,0
R_30_t0 \$30__t0 \$30 14.1887057143
* device instance _30_t1 r0 *1 0,0
R_30_t1 \$30__t1 \$30 20.61378
* device instance _30_t2 r0 *1 0,0
R_30_t2 \$30__t2 \$30 12.0470142857
* device instance _30_t3 r0 *1 0,0
R_30_t3 \$30__t3 \$30 15.6165
* device instance _30_t4 r0 *1 0,0
R_30_t4 \$30__t4 \$30 13.4748085714
* device instance _30_t5 r0 *1 0,0
R_30_t5 \$30__t5 \$30 17.7581914286
* device instance _30 r0 *1 0,0
C_30 \$30 vsubs 7.754828e-15
* device instance _32_t0 r0 *1 0,0
R_32_t0 \$32__t0 \$32 4.28
* device instance _32_t1 r0 *1 0,0
R_32_t1 \$32__t1 \$32 5.07751552795
* device instance _32_t2 r0 *1 0,0
R_32_t2 \$32__t2 \$32 3.48248447205
* device instance _32_t3 r0 *1 0,0
R_32_t3 \$32__t3 \$32 5.22372670807
* device instance _32_t4 r0 *1 0,0
R_32_t4 \$32__t4 \$32 7.61627329193
* device instance _32 r0 *1 0,0
C_32 \$32 vsubs 6.153234e-15
* device instance _33_t0 r0 *1 0,0
R_33_t0 \$33__t0 \$33 3.276
* device instance _33_t1 r0 *1 0,0
R_33_t1 \$33__t1 \$33 3.276
* device instance _33 r0 *1 0,0
C_33 \$33 vsubs 1.600958e-15
* device instance _34_t0 r0 *1 0,0
R_34_t0 \$34__t0 \$34 3.861
* device instance _34_t1 r0 *1 0,0
R_34_t1 \$34__t1 \$34 3.861
* device instance _34 r0 *1 0,0
C_34 \$34 vsubs 1.84239e-15
* device instance _35_t0 r0 *1 0,0
R_35_t0 \$35__t0 \$35 29.8356214885
* device instance _35_t1 r0 *1 0,0
R_35_t1 \$35__t1 \$35 33.5846001048
* device instance _35_t2 r0 *1 0,0
R_35_t2 \$35__t2 \$35 11.0907284067
* device instance _35_t3 r0 *1 0,0
R_35_t3 \$35__t3 \$35 33.5846001048
* device instance _35_t4 r0 *1 0,0
R_35_t4 \$35__t4 \$35 11.0907284067
* device instance _35_t5 r0 *1 0,0
R_35_t5 \$35__t5 \$35 29.8356214885
* device instance _35 r0 *1 0,0
C_35 \$35 vsubs 6.540865e-15
* device instance _36_t0 r0 *1 0,0
R_36_t0 \$36__t0 \$36 12.1810604326
* device instance _36_t1 r0 *1 0,0
R_36_t1 \$36__t1 \$36 9.63892608142
* device instance _36_t2 r0 *1 0,0
R_36_t2 \$36__t2 \$36 19.807463486
* device instance _36_t3 r0 *1 0,0
R_36_t3 \$36__t3 \$36 5.40203549618
* device instance _36_t4 r0 *1 0,0
R_36_t4 \$36__t4 \$36 20.6548416031
* device instance _36_t5 r0 *1 0,0
R_36_t5 \$36__t5 \$36 15.5705729008
* device instance _36 r0 *1 0,0
C_36 \$36 vsubs 6.157637e-15
* device instance _37_t0 r0 *1 0,0
R_37_t0 \$37__t0 \$37 4.77390718563
* device instance _37_t1 r0 *1 0,0
R_37_t1 \$37__t1 \$37 5.51309281437
* device instance _37_t2 r0 *1 0,0
R_37_t2 \$37__t2 \$37 4.77390718563
* device instance _37_t3 r0 *1 0,0
R_37_t3 \$37__t3 \$37 5.51309281437
* device instance _37 r0 *1 0,0
C_37 \$37 vsubs 4.965606e-15
* device instance _38_t0 r0 *1 0,0
R_38_t0 \$38__t0 \$38 14.1887057143
* device instance _38_t1 r0 *1 0,0
R_38_t1 \$38__t1 \$38 12.0470142857
* device instance _38_t2 r0 *1 0,0
R_38_t2 \$38__t2 \$38 20.61378
* device instance _38_t3 r0 *1 0,0
R_38_t3 \$38__t3 \$38 15.6165
* device instance _38_t4 r0 *1 0,0
R_38_t4 \$38__t4 \$38 17.7581914286
* device instance _38_t5 r0 *1 0,0
R_38_t5 \$38__t5 \$38 13.4748085714
* device instance _38 r0 *1 0,0
C_38 \$38 vsubs 7.754828e-15
* device instance _40_t0 r0 *1 0,0
R_40_t0 \$40__t0 \$40 4.28
* device instance _40_t1 r0 *1 0,0
R_40_t1 \$40__t1 \$40 5.07751552795
* device instance _40_t2 r0 *1 0,0
R_40_t2 \$40__t2 \$40 3.48248447205
* device instance _40_t3 r0 *1 0,0
R_40_t3 \$40__t3 \$40 5.22372670807
* device instance _40_t4 r0 *1 0,0
R_40_t4 \$40__t4 \$40 7.61627329193
* device instance _40 r0 *1 0,0
C_40 \$40 vsubs 6.153234e-15
* device instance _41_t0 r0 *1 0,0
R_41_t0 \$41__t0 \$41 3.276
* device instance _41_t1 r0 *1 0,0
R_41_t1 \$41__t1 \$41 3.276
* device instance _41 r0 *1 0,0
C_41 \$41 vsubs 1.600958e-15
* device instance _42_t0 r0 *1 0,0
R_42_t0 \$42__t0 \$42 3.861
* device instance _42_t1 r0 *1 0,0
R_42_t1 \$42__t1 \$42 3.861
* device instance _42 r0 *1 0,0
C_42 \$42 vsubs 1.84239e-15
* device instance _46_t0 r0 *1 0,0
R_46_t0 \$46__t0 \$46 11.8369301471
* device instance _46_t1 r0 *1 0,0
R_46_t1 \$46__t1 \$46 7.20148897059
* device instance _46_t2 r0 *1 0,0
R_46_t2 \$46__t2 \$46 9.51920955882
* device instance _46_t3 r0 *1 0,0
R_46_t3 \$46__t3 \$46 16.4723713235
* device instance _46_t4 r0 *1 0,0
R_46_t4 \$46__t4 \$46 8.82941176471
* device instance _46_t5 r0 *1 0,0
R_46_t5 \$46__t5 \$46 15.7825735294
* device instance _46_t6 r0 *1 0,0
R_46_t6 \$46__t6 \$46 20.4180147059
* device instance _46 r0 *1 0,0
C_46 \$46 vsubs 7.031849e-15
* device instance _48_t0 r0 *1 0,0
R_48_t0 \$48__t0 \$48 11.8369301471
* device instance _48_t1 r0 *1 0,0
R_48_t1 \$48__t1 \$48 7.20148897059
* device instance _48_t2 r0 *1 0,0
R_48_t2 \$48__t2 \$48 9.51920955882
* device instance _48_t3 r0 *1 0,0
R_48_t3 \$48__t3 \$48 16.4723713235
* device instance _48_t4 r0 *1 0,0
R_48_t4 \$48__t4 \$48 8.82941176471
* device instance _48_t5 r0 *1 0,0
R_48_t5 \$48__t5 \$48 15.7825735294
* device instance _48_t6 r0 *1 0,0
R_48_t6 \$48__t6 \$48 20.4180147059
* device instance _48 r0 *1 0,0
C_48 \$48 vsubs 7.031849e-15
* device instance _49_t0 r0 *1 0,0
R_49_t0 \$49__t0 \$49 11.8369301471
* device instance _49_t1 r0 *1 0,0
R_49_t1 \$49__t1 \$49 7.20148897059
* device instance _49_t2 r0 *1 0,0
R_49_t2 \$49__t2 \$49 9.51920955882
* device instance _49_t3 r0 *1 0,0
R_49_t3 \$49__t3 \$49 16.4723713235
* device instance _49_t4 r0 *1 0,0
R_49_t4 \$49__t4 \$49 8.82941176471
* device instance _49_t5 r0 *1 0,0
R_49_t5 \$49__t5 \$49 15.7825735294
* device instance _49_t6 r0 *1 0,0
R_49_t6 \$49__t6 \$49 20.4180147059
* device instance _49 r0 *1 0,0
C_49 \$49 vsubs 7.031849e-15
* device instance _5_t0 r0 *1 0,0
R_5_t0 \$5__t0 \$5 29.1833671687
* device instance _5_t1 r0 *1 0,0
R_5_t1 \$5__t1 \$5 29.1833671687
* device instance _5_t2 r0 *1 0,0
R_5_t2 \$5__t2 \$5 7.79708283133
* device instance _5_t3 r0 *1 0,0
R_5_t3 \$5__t3 \$5 7.79708283133
* device instance _5 r0 *1 0,0
C_5 \$5 vsubs 3.942747e-15
* device instance _50_t0 r0 *1 0,0
R_50_t0 \$50__t0 \$50 11.8369301471
* device instance _50_t1 r0 *1 0,0
R_50_t1 \$50__t1 \$50 7.20148897059
* device instance _50_t2 r0 *1 0,0
R_50_t2 \$50__t2 \$50 9.51920955882
* device instance _50_t3 r0 *1 0,0
R_50_t3 \$50__t3 \$50 16.4723713235
* device instance _50_t4 r0 *1 0,0
R_50_t4 \$50__t4 \$50 8.82941176471
* device instance _50_t5 r0 *1 0,0
R_50_t5 \$50__t5 \$50 15.7825735294
* device instance _50_t6 r0 *1 0,0
R_50_t6 \$50__t6 \$50 20.4180147059
* device instance _50 r0 *1 0,0
C_50 \$50 vsubs 7.031849e-15
* device instance _6_t0 r0 *1 0,0
R_6_t0 \$6__t0 \$6 7.87931174699
* device instance _6_t1 r0 *1 0,0
R_6_t1 \$6__t1 \$6 7.87931174699
* device instance _6_t2 r0 *1 0,0
R_6_t2 \$6__t2 \$6 29.491138253
* device instance _6_t3 r0 *1 0,0
R_6_t3 \$6__t3 \$6 29.491138253
* device instance _6 r0 *1 0,0
C_6 \$6 vsubs 4.105799e-15
* device instance _7_t0 r0 *1 0,0
R_7_t0 \$7__t0 \$7 2.952
* device instance _7_t1 r0 *1 0,0
R_7_t1 \$7__t1 \$7 2.952
* device instance _7 r0 *1 0,0
C_7 \$7 vsubs 1.470177e-15
* device instance _9_t0 r0 *1 0,0
R_9_t0 \$9__t0 \$9 3.147
* device instance _9_t1 r0 *1 0,0
R_9_t1 \$9__t1 \$9 3.147
* device instance _9 r0 *1 0,0
C_9 \$9 vsubs 1.55126e-15
* device instance a_t0 r0 *1 0,0
Ra_t0 a__t0 a 30.7674
* device instance a_t1 r0 *1 0,0
Ra_t1 a__t1 a 30.7674
* device instance a r0 *1 0,0
Ca a vsubs 5.85014e-16
* device instance a_dup1_t0 r0 *1 0,0
Ra_dup1_t0 a__t02 a$1 30.7674
* device instance a_dup1_t1 r0 *1 0,0
Ra_dup1_t1 a__t12 a$1 30.7674
* device instance a_dup1 r0 *1 0,0
Ca_dup1 a$1 vsubs 5.85014e-16
* device instance a_d_y_t0 r0 *1 0,0
Ra_d_y_t0 a|d|y__t0 a|d|y 28.8078612238
* device instance a_d_y_t1 r0 *1 0,0
Ra_d_y_t1 a|d|y__t1 a|d|y 20.1717712709
* device instance a_d_y_t2 r0 *1 0,0
Ra_d_y_t2 a|d|y__t2 a|d|y 17.9928796388
* device instance a_d_y_t3 r0 *1 0,0
Ra_d_y_t3 a|d|y__t3 a|d|y 12.6364378006
* device instance a_d_y_t4 r0 *1 0,0
Ra_d_y_t4 a|d|y__t4 a|d|y 28.8082131408
* device instance a_d_y_t5 r0 *1 0,0
Ra_d_y_t5 a|d|y__t5 a|d|y 65.9262268099
* device instance a_d_y_t6 r0 *1 0,0
Ra_d_y_t6 a|d|y__t6 a|d|y 52.9436638386
* device instance a_d_y_t7 r0 *1 0,0
Ra_d_y_t7 a|d|y__t7 a|d|y 10.4575462766
* device instance a_d_y r0 *1 0,0
Ca_d_y a|d|y vsubs 2.6876149e-14
* device instance b_d_y_t0 r0 *1 0,0
Rb_d_y_t0 b|d|y__t0 b|d|y 26.6822433305
* device instance b_d_y_t1 r0 *1 0,0
Rb_d_y_t1 b|d|y__t1 b|d|y 16.2657692451
* device instance b_d_y_t2 r0 *1 0,0
Rb_d_y_t2 b|d|y__t2 b|d|y 68.8000419015
* device instance b_d_y_t3 r0 *1 0,0
Rb_d_y_t3 b|d|y__t3 b|d|y 20.6006135414
* device instance b_d_y_t4 r0 *1 0,0
Rb_d_y_t4 b|d|y__t4 b|d|y 58.2935546842
* device instance b_d_y_t5 r0 *1 0,0
Rb_d_y_t5 b|d|y__t5 b|d|y 22.3639400446
* device instance b_d_y_t6 r0 *1 0,0
Rb_d_y_t6 b|d|y__t6 b|d|y 14.5024427666
* device instance b_d_y_t7 r0 *1 0,0
Rb_d_y_t7 b|d|y__t7 b|d|y 26.6819944861
* device instance b_d_y r0 *1 0,0
Cb_d_y b|d|y vsubs 3.0743586e-14
* device instance clk_t0 r0 *1 0,0
Rclk_t0 clk__t0 clk 61.1007062888
* device instance clk_t1 r0 *1 0,0
Rclk_t1 clk__t1 clk 62.5904375338
* device instance clk_t2 r0 *1 0,0
Rclk_t2 clk__t2 clk 14.4907399636
* device instance clk_t3 r0 *1 0,0
Rclk_t3 clk__t3 clk 75.998018738
* device instance clk_t4 r0 *1 0,0
Rclk_t4 clk__t4 clk 52.2864630898
* device instance clk_t5 r0 *1 0,0
Rclk_t5 clk__t5 clk 50.7967318448
* device instance clk_t6 r0 *1 0,0
Rclk_t6 clk__t6 clk 38.2022956118
* device instance clk_t7 r0 *1 0,0
Rclk_t7 clk__t7 clk 13.0010087186
* device instance clk_t8 r0 *1 0,0
Rclk_t8 clk__t8 clk 23.3049831626
* device instance clk_t9 r0 *1 0,0
Rclk_t9 clk__t9 clk 24.7947144076
* device instance clk_t10 r0 *1 0,0
Rclk_t10 clk__t10 clk 0.406572485591
* device instance clk_t11 r0 *1 0,0
Rclk_t11 clk__t11 clk 37.3891506406
* device instance clk_t12 r0 *1 0,0
Rclk_t12 clk__t12 clk 49.3070005999
* device instance clk_t13 r0 *1 0,0
Rclk_t13 clk__t13 clk 43.3480756203
* device instance clk_t14 r0 *1 0,0
Rclk_t14 clk__t14 clk 47.817269355
* device instance clk_t15 r0 *1 0,0
Rclk_t15 clk__t15 clk 11.5112774737
* device instance clk_t16 r0 *1 0,0
Rclk_t16 clk__t16 clk 10.0215462288
* device instance clk_t17 r0 *1 0,0
Rclk_t17 clk__t17 clk 5.55235249407
* device instance clk_t18 r0 *1 0,0
Rclk_t18 clk__t18 clk 70.0390937583
* device instance clk_t19 r0 *1 0,0
Rclk_t19 clk__t19 clk 65.5699000236
* device instance clk_t20 r0 *1 0,0
Rclk_t20 clk__t20 clk 64.0801687787
* device instance clk_t21 r0 *1 0,0
Rclk_t21 clk__t21 clk 32.2433706321
* device instance clk_t22 r0 *1 0,0
Rclk_t22 clk__t22 clk 27.7741768974
* device instance clk_t23 r0 *1 0,0
Rclk_t23 clk__t23 clk 26.2844456525
* device instance clk r0 *1 0,0
Cclk clk vsubs 4.2319148e-14
* device instance d_vdd_t0 r0 *1 0,0
Rd_vdd_t0 d|vdd__t0 d|vdd 4.31833147957
* device instance d_vdd_t1 r0 *1 0,0
Rd_vdd_t1 d|vdd__t1 d|vdd 4.31833147957
* device instance d_vdd_t2 r0 *1 0,0
Rd_vdd_t2 d|vdd__t2 d|vdd 4.48973987698
* device instance d_vdd_t3 r0 *1 0,0
Rd_vdd_t3 d|vdd__t3 d|vdd 4.48973987698
* device instance d_vdd_t4 r0 *1 0,0
Rd_vdd_t4 d|vdd__t4 d|vdd 5.76180744672
* device instance d_vdd_t5 r0 *1 0,0
Rd_vdd_t5 d|vdd__t5 d|vdd 5.76180744672
* device instance d_vdd_t6 r0 *1 0,0
Rd_vdd_t6 d|vdd__t6 d|vdd 5.41649568304
* device instance d_vdd_t7 r0 *1 0,0
Rd_vdd_t7 d|vdd__t7 d|vdd 5.41649568304
* device instance d_vdd_t8 r0 *1 0,0
Rd_vdd_t8 d|vdd__t8 d|vdd 2.37623871369
* device instance d_vdd_t9 r0 *1 0,0
Rd_vdd_t9 d|vdd__t9 d|vdd 3.77928778491
* device instance d_vdd_t10 r0 *1 0,0
Rd_vdd_t10 d|vdd__t10 d|vdd 3.8649919822
* device instance d_vdd_t11 r0 *1 0,0
Rd_vdd_t11 d|vdd__t11 d|vdd 3.95069617974
* device instance d_vdd_t12 r0 *1 0,0
Rd_vdd_t12 d|vdd__t12 d|vdd 4.03640037752
* device instance d_vdd_t13 r0 *1 0,0
Rd_vdd_t13 d|vdd__t13 d|vdd 4.12210457551
* device instance d_vdd_t14 r0 *1 0,0
Rd_vdd_t14 d|vdd__t14 d|vdd 4.2078087737
* device instance d_vdd_t15 r0 *1 0,0
Rd_vdd_t15 d|vdd__t15 d|vdd 4.29351297209
* device instance d_vdd_t16 r0 *1 0,0
Rd_vdd_t16 d|vdd__t16 d|vdd 4.37921717066
* device instance d_vdd_t17 r0 *1 0,0
Rd_vdd_t17 d|vdd__t17 d|vdd 0.569488284837
* device instance d_vdd_t18 r0 *1 0,0
Rd_vdd_t18 d|vdd__t18 d|vdd 4.5506255683
* device instance d_vdd_t19 r0 *1 0,0
Rd_vdd_t19 d|vdd__t19 d|vdd 4.63632976735
* device instance d_vdd_t20 r0 *1 0,0
Rd_vdd_t20 d|vdd__t20 d|vdd 4.40403567819
* device instance d_vdd_t21 r0 *1 0,0
Rd_vdd_t21 d|vdd__t21 d|vdd 2.74387397958
* device instance d_vdd_t22 r0 *1 0,0
Rd_vdd_t22 d|vdd__t22 d|vdd 2.65816978802
* device instance d_vdd_t23 r0 *1 0,0
Rd_vdd_t23 d|vdd__t23 d|vdd 2.57246559722
* device instance d_vdd_t24 r0 *1 0,0
Rd_vdd_t24 d|vdd__t24 d|vdd 2.40105721824
* device instance d_vdd_t25 r0 *1 0,0
Rd_vdd_t25 d|vdd__t25 d|vdd 2.46194290242
* device instance d_vdd_t26 r0 *1 0,0
Rd_vdd_t26 d|vdd__t26 d|vdd 0.483784384916
* device instance d_vdd_t27 r0 *1 0,0
Rd_vdd_t27 d|vdd__t27 d|vdd 0.3980806155
* device instance d_vdd_t28 r0 *1 0,0
Rd_vdd_t28 d|vdd__t28 d|vdd 0.312377084007
* device instance d_vdd_t29 r0 *1 0,0
Rd_vdd_t29 d|vdd__t29 d|vdd 0.226674060307
* device instance d_vdd_t30 r0 *1 0,0
Rd_vdd_t30 d|vdd__t30 d|vdd 0.140972470526
* device instance d_vdd_t31 r0 *1 0,0
Rd_vdd_t31 d|vdd__t31 d|vdd 0.0552789842831
* device instance d_vdd_t32 r0 *1 0,0
Rd_vdd_t32 d|vdd__t32 d|vdd 0.0304748353199
* device instance d_vdd_t33 r0 *1 0,0
Rd_vdd_t33 d|vdd__t33 d|vdd 0.116155438527
* device instance d_vdd_t34 r0 *1 0,0
Rd_vdd_t34 d|vdd__t34 d|vdd 0.201856080012
* device instance d_vdd_t35 r0 *1 0,0
Rd_vdd_t35 d|vdd__t35 d|vdd 2.48676140726
* device instance d_vdd_t36 r0 *1 0,0
Rd_vdd_t36 d|vdd__t36 d|vdd 1.60490108366
* device instance d_vdd_t37 r0 *1 0,0
Rd_vdd_t37 d|vdd__t37 d|vdd 1.6906052559
* device instance d_vdd_t38 r0 *1 0,0
Rd_vdd_t38 d|vdd__t38 d|vdd 1.7763094311
* device instance d_vdd_t39 r0 *1 0,0
Rd_vdd_t39 d|vdd__t39 d|vdd 1.86201360886
* device instance d_vdd_t40 r0 *1 0,0
Rd_vdd_t40 d|vdd__t40 d|vdd 1.94771778885
* device instance d_vdd_t41 r0 *1 0,0
Rd_vdd_t41 d|vdd__t41 d|vdd 2.03342197078
* device instance d_vdd_t42 r0 *1 0,0
Rd_vdd_t42 d|vdd__t42 d|vdd 2.11912615441
* device instance d_vdd_t43 r0 *1 0,0
Rd_vdd_t43 d|vdd__t43 d|vdd 2.20483033954
* device instance d_vdd_t44 r0 *1 0,0
Rd_vdd_t44 d|vdd__t44 d|vdd 2.29053452602
* device instance d_vdd_t45 r0 *1 0,0
Rd_vdd_t45 d|vdd__t45 d|vdd 0.287558844419
* device instance d_vdd_t46 r0 *1 0,0
Rd_vdd_t46 d|vdd__t46 d|vdd 4.4649213694
* device instance d_vdd_t47 r0 *1 0,0
Rd_vdd_t47 d|vdd__t47 d|vdd 1.88683211077
* device instance d_vdd_t48 r0 *1 0,0
Rd_vdd_t48 d|vdd__t48 d|vdd 1.97253629134
* device instance d_vdd_t49 r0 *1 0,0
Rd_vdd_t49 d|vdd__t49 d|vdd 2.05824047379
* device instance d_vdd_t50 r0 *1 0,0
Rd_vdd_t50 d|vdd__t50 d|vdd 2.14394465787
* device instance d_vdd_t51 r0 *1 0,0
Rd_vdd_t51 d|vdd__t51 d|vdd 2.22964884341
* device instance d_vdd_t52 r0 *1 0,0
Rd_vdd_t52 d|vdd__t52 d|vdd 2.31535303025
* device instance d_vdd_t53 r0 *1 0,0
Rd_vdd_t53 d|vdd__t53 d|vdd 2.37623871369
* device instance d_vdd_t54 r0 *1 0,0
Rd_vdd_t54 d|vdd__t54 d|vdd 3.77928778491
* device instance d_vdd_t55 r0 *1 0,0
Rd_vdd_t55 d|vdd__t55 d|vdd 3.95069617974
* device instance d_vdd_t56 r0 *1 0,0
Rd_vdd_t56 d|vdd__t56 d|vdd 4.03640037752
* device instance d_vdd_t57 r0 *1 0,0
Rd_vdd_t57 d|vdd__t57 d|vdd 4.12210457551
* device instance d_vdd_t58 r0 *1 0,0
Rd_vdd_t58 d|vdd__t58 d|vdd 4.37921717066
* device instance d_vdd_t59 r0 *1 0,0
Rd_vdd_t59 d|vdd__t59 d|vdd 0.569488284837
* device instance d_vdd_t60 r0 *1 0,0
Rd_vdd_t60 d|vdd__t60 d|vdd 4.5506255683
* device instance d_vdd_t61 r0 *1 0,0
Rd_vdd_t61 d|vdd__t61 d|vdd 4.40403567819
* device instance d_vdd_t62 r0 *1 0,0
Rd_vdd_t62 d|vdd__t62 d|vdd 2.74387397958
* device instance d_vdd_t63 r0 *1 0,0
Rd_vdd_t63 d|vdd__t63 d|vdd 2.57246559722
* device instance d_vdd_t64 r0 *1 0,0
Rd_vdd_t64 d|vdd__t64 d|vdd 2.40105721824
* device instance d_vdd_t65 r0 *1 0,0
Rd_vdd_t65 d|vdd__t65 d|vdd 0.3980806155
* device instance d_vdd_t66 r0 *1 0,0
Rd_vdd_t66 d|vdd__t66 d|vdd 0.312377084007
* device instance d_vdd_t67 r0 *1 0,0
Rd_vdd_t67 d|vdd__t67 d|vdd 0.226674060307
* device instance d_vdd_t68 r0 *1 0,0
Rd_vdd_t68 d|vdd__t68 d|vdd 0.0304748353199
* device instance d_vdd_t69 r0 *1 0,0
Rd_vdd_t69 d|vdd__t69 d|vdd 0.116155438527
* device instance d_vdd_t70 r0 *1 0,0
Rd_vdd_t70 d|vdd__t70 d|vdd 0.201856080012
* device instance d_vdd_t71 r0 *1 0,0
Rd_vdd_t71 d|vdd__t71 d|vdd 2.48676140726
* device instance d_vdd_t72 r0 *1 0,0
Rd_vdd_t72 d|vdd__t72 d|vdd 1.60490108366
* device instance d_vdd_t73 r0 *1 0,0
Rd_vdd_t73 d|vdd__t73 d|vdd 1.7763094311
* device instance d_vdd_t74 r0 *1 0,0
Rd_vdd_t74 d|vdd__t74 d|vdd 1.86201360886
* device instance d_vdd_t75 r0 *1 0,0
Rd_vdd_t75 d|vdd__t75 d|vdd 1.94771778885
* device instance d_vdd_t76 r0 *1 0,0
Rd_vdd_t76 d|vdd__t76 d|vdd 2.20483033954
* device instance d_vdd_t77 r0 *1 0,0
Rd_vdd_t77 d|vdd__t77 d|vdd 2.29053452602
* device instance d_vdd_t78 r0 *1 0,0
Rd_vdd_t78 d|vdd__t78 d|vdd 4.4649213694
* device instance d_vdd_t79 r0 *1 0,0
Rd_vdd_t79 d|vdd__t79 d|vdd 1.97253629134
* device instance d_vdd_t80 r0 *1 0,0
Rd_vdd_t80 d|vdd__t80 d|vdd 2.05824047379
* device instance d_vdd_t81 r0 *1 0,0
Rd_vdd_t81 d|vdd__t81 d|vdd 2.14394465787
* device instance d_vdd_t82 r0 *1 0,0
Rd_vdd_t82 d|vdd__t82 d|vdd 0.483784384916
* device instance d_vdd_t83 r0 *1 0,0
Rd_vdd_t83 d|vdd__t83 d|vdd 1.5050914375
* device instance d_vdd_t84 r0 *1 0,0
Rd_vdd_t84 d|vdd__t84 d|vdd 4.23262728113
* device instance d_vdd_t85 r0 *1 0,0
Rd_vdd_t85 d|vdd__t85 d|vdd 4.06121888483
* device instance d_vdd_t86 r0 *1 0,0
Rd_vdd_t86 d|vdd__t86 d|vdd 4.14692308288
* device instance d_vdd_t87 r0 *1 0,0
Rd_vdd_t87 d|vdd__t87 d|vdd 4.23262728113
* device instance d_vdd r0 *1 0,0
Cd_vdd d|vdd vsubs 5.4950234e-14
* device instance d_y_t0 r0 *1 0,0
Rd_y_t0 d|y__t0 d|y 1.73192783825
* device instance d_y_t1 r0 *1 0,0
Rd_y_t1 d|y__t1 d|y 20.8553729678
* device instance d_y_t2 r0 *1 0,0
Rd_y_t2 d|y__t2 d|y 10.7256719826
* device instance d_y_t3 r0 *1 0,0
Rd_y_t3 d|y__t3 d|y 13.3262726991
* device instance d_y_t4 r0 *1 0,0
Rd_y_t4 d|y__t4 d|y 5.36012703224
* device instance d_y_t5 r0 *1 0,0
Rd_y_t5 d|y__t5 d|y 0.431627480022
* device instance d_y r0 *1 0,0
Cd_y d|y vsubs 1.2652967e-14
* device instance q_t0 r0 *1 0,0
Rq_t0 q__t0 q 20.2824612416
* device instance q_t1 r0 *1 0,0
Rq_t1 q__t1 q 17.2589887584
* device instance q_t2 r0 *1 0,0
Rq_t2 q__t2 q 12.7237800336
* device instance q_t3 r0 *1 0,0
Rq_t3 q__t3 q 24.8176699664
* device instance q r0 *1 0,0
Cq q vsubs 4.230534e-15
* device instance q_dup1_t0 r0 *1 0,0
Rq_dup1_t0 q__t02 q$1 20.2824612416
* device instance q_dup1_t1 r0 *1 0,0
Rq_dup1_t1 q__t12 q$1 17.2589887584
* device instance q_dup1_t2 r0 *1 0,0
Rq_dup1_t2 q__t22 q$1 12.7237800336
* device instance q_dup1_t3 r0 *1 0,0
Rq_dup1_t3 q__t32 q$1 24.8176699664
* device instance q_dup1 r0 *1 0,0
Cq_dup1 q$1 vsubs 4.230534e-15
* device instance q_dup2_t0 r0 *1 0,0
Rq_dup2_t0 q__t03 q$2 20.2824612416
* device instance q_dup2_t1 r0 *1 0,0
Rq_dup2_t1 q__t13 q$2 17.2589887584
* device instance q_dup2_t2 r0 *1 0,0
Rq_dup2_t2 q__t23 q$2 12.7237800336
* device instance q_dup2_t3 r0 *1 0,0
Rq_dup2_t3 q__t33 q$2 24.8176699664
* device instance q_dup2 r0 *1 0,0
Cq_dup2 q$2 vsubs 4.230534e-15
* device instance q_dup3_t0 r0 *1 0,0
Rq_dup3_t0 q__t04 q$3 20.2824612416
* device instance q_dup3_t1 r0 *1 0,0
Rq_dup3_t1 q__t14 q$3 17.2589887584
* device instance q_dup3_t2 r0 *1 0,0
Rq_dup3_t2 q__t24 q$3 12.7237800336
* device instance q_dup3_t3 r0 *1 0,0
Rq_dup3_t3 q__t34 q$3 24.8176699664
* device instance q_dup3 r0 *1 0,0
Cq_dup3 q$3 vsubs 4.230534e-15
* device instance rst_n_t0 r0 *1 0,0
Rrst_n_t0 rst_n__t0 rst_n 30.084525214
* device instance rst_n_t1 r0 *1 0,0
Rrst_n_t1 rst_n__t1 rst_n 59.0147057332
* device instance rst_n_t2 r0 *1 0,0
Rrst_n_t2 rst_n__t2 rst_n 67.975656464
* device instance rst_n_t3 r0 *1 0,0
Rrst_n_t3 rst_n__t3 rst_n 16.7675567668
* device instance rst_n_t4 r0 *1 0,0
Rrst_n_t4 rst_n__t4 rst_n 7.80660603599
* device instance rst_n_t5 r0 *1 0,0
Rrst_n_t5 rst_n__t5 rst_n 54.6586880168
* device instance rst_n_t6 r0 *1 0,0
Rrst_n_t6 rst_n__t6 rst_n 21.1235744832
* device instance rst_n_t7 r0 *1 0,0
Rrst_n_t7 rst_n__t7 rst_n 45.697737286
* device instance rst_n_t8 r0 *1 0,0
Rrst_n_t8 rst_n__t8 rst_n 51.6717044399
* device instance rst_n_t9 r0 *1 0,0
Rrst_n_t9 rst_n__t9 rst_n 48.6847208629
* device instance rst_n_t10 r0 *1 0,0
Rrst_n_t10 rst_n__t10 rst_n 13.7805731899
* device instance rst_n_t11 r0 *1 0,0
Rrst_n_t11 rst_n__t11 rst_n 64.9886728871
* device instance rst_n_t12 r0 *1 0,0
Rrst_n_t12 rst_n__t12 rst_n 24.1105580601
* device instance rst_n_t13 r0 *1 0,0
Rrst_n_t13 rst_n__t13 rst_n 27.0975416371
* device instance rst_n_t14 r0 *1 0,0
Rrst_n_t14 rst_n__t14 rst_n 62.0016893101
* device instance rst_n_t15 r0 *1 0,0
Rrst_n_t15 rst_n__t15 rst_n 10.7935896129
* device instance rst_n r0 *1 0,0
Crst_n rst_n vsubs 3.4164692e-14
* device instance vss_t0 r0 *1 0,0
Rvss_t0 vss__t0 vss 5.85729212044
* device instance vss_t1 r0 *1 0,0
Rvss_t1 vss__t1 vss 5.02637221962
* device instance vss_t2 r0 *1 0,0
Rvss_t2 vss__t2 vss 4.71186207885
* device instance vss_t3 r0 *1 0,0
Rvss_t3 vss__t3 vss 5.61280819258
* device instance vss_t4 r0 *1 0,0
Rvss_t4 vss__t4 vss 5.40313476244
* device instance vss_t5 r0 *1 0,0
Rvss_t5 vss__t5 vss 2.95301347841
* device instance vss_t6 r0 *1 0,0
Rvss_t6 vss__t6 vss 2.57625099001
* device instance vss_t7 r0 *1 0,0
Rvss_t7 vss__t7 vss 4.50218865325
* device instance vss_t8 r0 *1 0,0
Rvss_t8 vss__t8 vss 0.293223208295
* device instance vss_t9 r0 *1 0,0
Rvss_t9 vss__t9 vss 0.0835628312378
* device instance vss_t10 r0 *1 0,0
Rvss_t10 vss__t10 vss 2.36657760181
* device instance vss_t11 r0 *1 0,0
Rvss_t11 vss__t11 vss 2.74334007722
* device instance vss_t12 r0 *1 0,0
Rvss_t12 vss__t12 vss 5.08862461886
* device instance vss_t13 r0 *1 0,0
Rvss_t13 vss__t13 vss 4.56444105158
* device instance vss_t14 r0 *1 0,0
Rvss_t14 vss__t14 vss 2.42882998824
* device instance vss_t15 r0 *1 0,0
Rvss_t15 vss__t15 vss 2.11431992068
* device instance vss_t16 r0 *1 0,0
Rvss_t16 vss__t16 vss 1.90464655947
* device instance vss_t17 r0 *1 0,0
Rvss_t17 vss__t17 vss 4.92153550574
* device instance vss_t18 r0 *1 0,0
Rvss_t18 vss__t18 vss 3.41494460726
* device instance vss_t19 r0 *1 0,0
Rvss_t19 vss__t19 vss 3.20527119581
* device instance vss_t20 r0 *1 0,0
Rvss_t20 vss__t20 vss 2.89076108658
* device instance vss_t21 r0 *1 0,0
Rvss_t21 vss__t21 vss 0.755151222564
* device instance vss_t22 r0 *1 0,0
Rvss_t22 vss__t22 vss 4.77411447759
* device instance vss_t23 r0 *1 0,0
Rvss_t23 vss__t23 vss 0.545478558881
* device instance vss_t24 r0 *1 0,0
Rvss_t24 vss__t24 vss 0.230972208466
* device instance vss_t25 r0 *1 0,0
Rvss_t25 vss__t25 vss 5.43489443375
* device instance vss_t26 r0 *1 0,0
Rvss_t26 vss__t26 vss 5.85729212044
* device instance vss_t27 r0 *1 0,0
Rvss_t27 vss__t27 vss 5.43489443375
* device instance vss_t28 r0 *1 0,0
Rvss_t28 vss__t28 vss 4.81669879215
* device instance vss_t29 r0 *1 0,0
Rvss_t29 vss__t29 vss 4.71186207885
* device instance vss_t30 r0 *1 0,0
Rvss_t30 vss__t30 vss 4.60702536588
* device instance vss_t31 r0 *1 0,0
Rvss_t31 vss__t31 vss 4.50218865325
* device instance vss_t32 r0 *1 0,0
Rvss_t32 vss__t32 vss 2.68108768719
* device instance vss_t33 r0 *1 0,0
Rvss_t33 vss__t33 vss 2.57625099001
* device instance vss_t34 r0 *1 0,0
Rvss_t34 vss__t34 vss 2.4714142948
* device instance vss_t35 r0 *1 0,0
Rvss_t35 vss__t35 vss 2.36657760181
* device instance vss_t36 r0 *1 0,0
Rvss_t36 vss__t36 vss 0.0213637310558
* device instance vss_t37 r0 *1 0,0
Rvss_t37 vss__t37 vss 0.0835628312378
* device instance vss_t38 r0 *1 0,0
Rvss_t38 vss__t38 vss 0.188389385026
* device instance vss_t39 r0 *1 0,0
Rvss_t39 vss__t39 vss 0.293223208295
* device instance vss_t40 r0 *1 0,0
Rvss_t40 vss__t40 vss 2.63850337899
* device instance vss_t41 r0 *1 0,0
Rvss_t41 vss__t41 vss 2.74334007722
* device instance vss_t42 r0 *1 0,0
Rvss_t42 vss__t42 vss 2.84817677709
* device instance vss_t43 r0 *1 0,0
Rvss_t43 vss__t43 vss 2.95301347841
* device instance vss_t44 r0 *1 0,0
Rvss_t44 vss__t44 vss 5.29829804769
* device instance vss_t45 r0 *1 0,0
Rvss_t45 vss__t45 vss 5.40313476244
* device instance vss_t46 r0 *1 0,0
Rvss_t46 vss__t46 vss 5.50797147741
* device instance vss_t47 r0 *1 0,0
Rvss_t47 vss__t47 vss 5.61280819258
* device instance vss_t48 r0 *1 0,0
Rvss_t48 vss__t48 vss 5.02637221962
* device instance vss_t49 r0 *1 0,0
Rvss_t49 vss__t49 vss 4.92153550574
* device instance vss_t50 r0 *1 0,0
Rvss_t50 vss__t50 vss 3.41494460726
* device instance vss_t51 r0 *1 0,0
Rvss_t51 vss__t51 vss 3.31010790107
* device instance vss_t52 r0 *1 0,0
Rvss_t52 vss__t52 vss 3.20527119581
* device instance vss_t53 r0 *1 0,0
Rvss_t53 vss__t53 vss 3.10043449157
* device instance vss_t54 r0 *1 0,0
Rvss_t54 vss__t54 vss 2.99559778845
* device instance vss_t55 r0 *1 0,0
Rvss_t55 vss__t55 vss 2.89076108658
* device instance vss_t56 r0 *1 0,0
Rvss_t56 vss__t56 vss 2.78592438611
* device instance vss_t57 r0 *1 0,0
Rvss_t57 vss__t57 vss 0.755151222564
* device instance vss_t58 r0 *1 0,0
Rvss_t58 vss__t58 vss 0.650314828092
* device instance vss_t59 r0 *1 0,0
Rvss_t59 vss__t59 vss 0.545478558881
* device instance vss_t60 r0 *1 0,0
Rvss_t60 vss__t60 vss 0.440642504336
* device instance vss_t61 r0 *1 0,0
Rvss_t61 vss__t61 vss 0.335806865508
* device instance vss_t62 r0 *1 0,0
Rvss_t62 vss__t62 vss 0.230972208466
* device instance vss_t63 r0 *1 0,0
Rvss_t63 vss__t63 vss 0.126140981093
* device instance vss_t64 r0 *1 0,0
Rvss_t64 vss__t64 vss 1.90464655947
* device instance vss_t65 r0 *1 0,0
Rvss_t65 vss__t65 vss 2.009483238
* device instance vss_t66 r0 *1 0,0
Rvss_t66 vss__t66 vss 2.11431992068
* device instance vss_t67 r0 *1 0,0
Rvss_t67 vss__t67 vss 2.21915660692
* device instance vss_t68 r0 *1 0,0
Rvss_t68 vss__t68 vss 2.32399329624
* device instance vss_t69 r0 *1 0,0
Rvss_t69 vss__t69 vss 2.42882998824
* device instance vss_t70 r0 *1 0,0
Rvss_t70 vss__t70 vss 2.53366668258
* device instance vss_t71 r0 *1 0,0
Rvss_t71 vss__t71 vss 4.56444105158
* device instance vss_t72 r0 *1 0,0
Rvss_t72 vss__t72 vss 4.66927776442
* device instance vss_t73 r0 *1 0,0
Rvss_t73 vss__t73 vss 4.77411447759
* device instance vss_t74 r0 *1 0,0
Rvss_t74 vss__t74 vss 4.87895119106
* device instance vss_t75 r0 *1 0,0
Rvss_t75 vss__t75 vss 4.98378790483
* device instance vss_t76 r0 *1 0,0
Rvss_t76 vss__t76 vss 5.08862461886
* device instance vss_t77 r0 *1 0,0
Rvss_t77 vss__t77 vss 5.19346133316
* device instance vss r0 *1 0,0
Cvss vss vsubs 5.8121705e-14
* device instance cc__10__5 r0 *1 0,0
Ccc__10__5 \$10 \$5 1.5937e-17
* device instance cc__10__6 r0 *1 0,0
Ccc__10__6 \$10 \$6 2.125e-17
* device instance cc__10_a_d_y r0 *1 0,0
Ccc__10_a_d_y \$10 a|d|y 2.125e-17
* device instance cc__10_b_d_y r0 *1 0,0
Ccc__10_b_d_y \$10 b|d|y 2.125e-17
* device instance cc__10_d_vdd r0 *1 0,0
Ccc__10_d_vdd \$10 d|vdd 2.125e-17
* device instance cc__10_d_y r0 *1 0,0
Ccc__10_d_y \$10 d|y 2.125e-17
* device instance cc__10_vss r0 *1 0,0
Ccc__10_vss \$10 vss 2.125e-17
* device instance cc__11__12 r0 *1 0,0
Ccc__11__12 \$11 \$12 3.1875e-17
* device instance cc__11__13 r0 *1 0,0
Ccc__11__13 \$11 \$13 2.125e-17
* device instance cc__11__14 r0 *1 0,0
Ccc__11__14 \$11 \$14 2.125e-17
* device instance cc__11__16 r0 *1 0,0
Ccc__11__16 \$11 \$16 1.0625e-17
* device instance cc__11__17 r0 *1 0,0
Ccc__11__17 \$11 \$17 1.0625e-17
* device instance cc__11__18 r0 *1 0,0
Ccc__11__18 \$11 \$18 1.0625e-17
* device instance cc__11__46 r0 *1 0,0
Ccc__11__46 \$11 \$46 3.1875e-17
* device instance cc__11_clk r0 *1 0,0
Ccc__11_clk \$11 clk 3.1875e-17
* device instance cc__11_d_vdd r0 *1 0,0
Ccc__11_d_vdd \$11 d|vdd 1.5937e-17
* device instance cc__11_d_y r0 *1 0,0
Ccc__11_d_y \$11 d|y 2.125e-17
* device instance cc__11_q r0 *1 0,0
Ccc__11_q \$11 q$3 2.125e-17
* device instance cc__11_rst_n r0 *1 0,0
Ccc__11_rst_n \$11 rst_n 1.5937e-17
* device instance cc__11_vss r0 *1 0,0
Ccc__11_vss \$11 vss 3.1875e-17
* device instance cc__12__13 r0 *1 0,0
Ccc__12__13 \$12 \$13 1.5937e-17
* device instance cc__12__14 r0 *1 0,0
Ccc__12__14 \$12 \$14 1.5937e-17
* device instance cc__12__16 r0 *1 0,0
Ccc__12__16 \$12 \$16 1.0625e-17
* device instance cc__12__17 r0 *1 0,0
Ccc__12__17 \$12 \$17 1.0625e-17
* device instance cc__12__18 r0 *1 0,0
Ccc__12__18 \$12 \$18 1.0625e-17
* device instance cc__12__46 r0 *1 0,0
Ccc__12__46 \$12 \$46 3.1875e-17
* device instance cc__12_clk r0 *1 0,0
Ccc__12_clk \$12 clk 3.1875e-17
* device instance cc__12_d_vdd r0 *1 0,0
Ccc__12_d_vdd \$12 d|vdd 1.5937e-17
* device instance cc__12_d_y r0 *1 0,0
Ccc__12_d_y \$12 d|y 2.6562e-17
* device instance cc__12_q r0 *1 0,0
Ccc__12_q \$12 q$3 2.125e-17
* device instance cc__12_rst_n r0 *1 0,0
Ccc__12_rst_n \$12 rst_n 1.5937e-17
* device instance cc__12_vss r0 *1 0,0
Ccc__12_vss \$12 vss 3.1875e-17
* device instance cc__13__14 r0 *1 0,0
Ccc__13__14 \$13 \$14 1.5937e-17
* device instance cc__13__16 r0 *1 0,0
Ccc__13__16 \$13 \$16 1.0625e-17
* device instance cc__13__17 r0 *1 0,0
Ccc__13__17 \$13 \$17 1.0625e-17
* device instance cc__13__18 r0 *1 0,0
Ccc__13__18 \$13 \$18 1.0625e-17
* device instance cc__13__46 r0 *1 0,0
Ccc__13__46 \$13 \$46 2.125e-17
* device instance cc__13_clk r0 *1 0,0
Ccc__13_clk \$13 clk 2.125e-17
* device instance cc__13_d_vdd r0 *1 0,0
Ccc__13_d_vdd \$13 d|vdd 1.0625e-17
* device instance cc__13_d_y r0 *1 0,0
Ccc__13_d_y \$13 d|y 2.125e-17
* device instance cc__13_q r0 *1 0,0
Ccc__13_q \$13 q$3 1.0625e-17
* device instance cc__13_rst_n r0 *1 0,0
Ccc__13_rst_n \$13 rst_n 1.0625e-17
* device instance cc__13_vss r0 *1 0,0
Ccc__13_vss \$13 vss 2.125e-17
* device instance cc__14__16 r0 *1 0,0
Ccc__14__16 \$14 \$16 1.5937e-17
* device instance cc__14__18 r0 *1 0,0
Ccc__14__18 \$14 \$18 1.0625e-17
* device instance cc__14__46 r0 *1 0,0
Ccc__14__46 \$14 \$46 2.125e-17
* device instance cc__14_clk r0 *1 0,0
Ccc__14_clk \$14 clk 3.1875e-17
* device instance cc__14_d_vdd r0 *1 0,0
Ccc__14_d_vdd \$14 d|vdd 1.5937e-17
* device instance cc__14_d_y r0 *1 0,0
Ccc__14_d_y \$14 d|y 3.1875e-17
* device instance cc__14_q r0 *1 0,0
Ccc__14_q \$14 q$3 1.5937e-17
* device instance cc__14_rst_n r0 *1 0,0
Ccc__14_rst_n \$14 rst_n 1.5937e-17
* device instance cc__14_vss r0 *1 0,0
Ccc__14_vss \$14 vss 3.1875e-17
* device instance cc__16__18 r0 *1 0,0
Ccc__16__18 \$16 \$18 1.0625e-17
* device instance cc__16__46 r0 *1 0,0
Ccc__16__46 \$16 \$46 1.0625e-17
* device instance cc__16_clk r0 *1 0,0
Ccc__16_clk \$16 clk 2.6562e-17
* device instance cc__16_d_vdd r0 *1 0,0
Ccc__16_d_vdd \$16 d|vdd 1.5937e-17
* device instance cc__16_d_y r0 *1 0,0
Ccc__16_d_y \$16 d|y 2.6562e-17
* device instance cc__16_q r0 *1 0,0
Ccc__16_q \$16 q$3 1.0625e-17
* device instance cc__16_rst_n r0 *1 0,0
Ccc__16_rst_n \$16 rst_n 2.125e-17
* device instance cc__16_vss r0 *1 0,0
Ccc__16_vss \$16 vss 2.6562e-17
* device instance cc__17__46 r0 *1 0,0
Ccc__17__46 \$17 \$46 1.0625e-17
* device instance cc__17_clk r0 *1 0,0
Ccc__17_clk \$17 clk 1.0625e-17
* device instance cc__17_d_y r0 *1 0,0
Ccc__17_d_y \$17 d|y 1.0625e-17
* device instance cc__17_q r0 *1 0,0
Ccc__17_q \$17 q$3 1.0625e-17
* device instance cc__17_rst_n r0 *1 0,0
Ccc__17_rst_n \$17 rst_n 5.312e-18
* device instance cc__17_vss r0 *1 0,0
Ccc__17_vss \$17 vss 1.0625e-17
* device instance cc__18__46 r0 *1 0,0
Ccc__18__46 \$18 \$46 1.0625e-17
* device instance cc__18_clk r0 *1 0,0
Ccc__18_clk \$18 clk 1.0625e-17
* device instance cc__18_d_y r0 *1 0,0
Ccc__18_d_y \$18 d|y 1.0625e-17
* device instance cc__18_q r0 *1 0,0
Ccc__18_q \$18 q$3 1.0625e-17
* device instance cc__18_rst_n r0 *1 0,0
Ccc__18_rst_n \$18 rst_n 1.0625e-17
* device instance cc__18_vss r0 *1 0,0
Ccc__18_vss \$18 vss 1.0625e-17
* device instance cc__19__20 r0 *1 0,0
Ccc__19__20 \$19 \$20 3.1875e-17
* device instance cc__19__21 r0 *1 0,0
Ccc__19__21 \$19 \$21 2.125e-17
* device instance cc__19__22 r0 *1 0,0
Ccc__19__22 \$19 \$22 2.125e-17
* device instance cc__19__24 r0 *1 0,0
Ccc__19__24 \$19 \$24 1.0625e-17
* device instance cc__19__25 r0 *1 0,0
Ccc__19__25 \$19 \$25 1.0625e-17
* device instance cc__19__26 r0 *1 0,0
Ccc__19__26 \$19 \$26 1.0625e-17
* device instance cc__19__48 r0 *1 0,0
Ccc__19__48 \$19 \$48 3.1875e-17
* device instance cc__19_clk r0 *1 0,0
Ccc__19_clk \$19 clk 3.1875e-17
* device instance cc__19_d_vdd r0 *1 0,0
Ccc__19_d_vdd \$19 d|vdd 3.7187e-17
* device instance cc__19_q r0 *1 0,0
Ccc__19_q \$19 q$3 2.125e-17
* device instance cc__19_rst_n r0 *1 0,0
Ccc__19_rst_n \$19 rst_n 1.5937e-17
* device instance cc__19_vss r0 *1 0,0
Ccc__19_vss \$19 vss 3.1875e-17
* device instance cc__20__21 r0 *1 0,0
Ccc__20__21 \$20 \$21 1.5937e-17
* device instance cc__20__22 r0 *1 0,0
Ccc__20__22 \$20 \$22 1.5937e-17
* device instance cc__20__24 r0 *1 0,0
Ccc__20__24 \$20 \$24 1.0625e-17
* device instance cc__20__25 r0 *1 0,0
Ccc__20__25 \$20 \$25 1.0625e-17
* device instance cc__20__26 r0 *1 0,0
Ccc__20__26 \$20 \$26 1.0625e-17
* device instance cc__20__48 r0 *1 0,0
Ccc__20__48 \$20 \$48 3.1875e-17
* device instance cc__20_clk r0 *1 0,0
Ccc__20_clk \$20 clk 3.1875e-17
* device instance cc__20_d_vdd r0 *1 0,0
Ccc__20_d_vdd \$20 d|vdd 4.2499e-17
* device instance cc__20_q r0 *1 0,0
Ccc__20_q \$20 q$3 2.125e-17
* device instance cc__20_rst_n r0 *1 0,0
Ccc__20_rst_n \$20 rst_n 1.5937e-17
* device instance cc__20_vss r0 *1 0,0
Ccc__20_vss \$20 vss 3.1875e-17
* device instance cc__21__22 r0 *1 0,0
Ccc__21__22 \$21 \$22 1.5937e-17
* device instance cc__21__24 r0 *1 0,0
Ccc__21__24 \$21 \$24 1.0625e-17
* device instance cc__21__25 r0 *1 0,0
Ccc__21__25 \$21 \$25 1.0625e-17
* device instance cc__21__26 r0 *1 0,0
Ccc__21__26 \$21 \$26 1.0625e-17
* device instance cc__21__48 r0 *1 0,0
Ccc__21__48 \$21 \$48 2.125e-17
* device instance cc__21_clk r0 *1 0,0
Ccc__21_clk \$21 clk 2.125e-17
* device instance cc__21_d_vdd r0 *1 0,0
Ccc__21_d_vdd \$21 d|vdd 3.1875e-17
* device instance cc__21_q r0 *1 0,0
Ccc__21_q \$21 q$3 1.0625e-17
* device instance cc__21_rst_n r0 *1 0,0
Ccc__21_rst_n \$21 rst_n 1.0625e-17
* device instance cc__21_vss r0 *1 0,0
Ccc__21_vss \$21 vss 2.125e-17
* device instance cc__22__24 r0 *1 0,0
Ccc__22__24 \$22 \$24 1.5937e-17
* device instance cc__22__26 r0 *1 0,0
Ccc__22__26 \$22 \$26 1.0625e-17
* device instance cc__22__48 r0 *1 0,0
Ccc__22__48 \$22 \$48 2.125e-17
* device instance cc__22_clk r0 *1 0,0
Ccc__22_clk \$22 clk 3.1875e-17
* device instance cc__22_d_vdd r0 *1 0,0
Ccc__22_d_vdd \$22 d|vdd 4.7812e-17
* device instance cc__22_q r0 *1 0,0
Ccc__22_q \$22 q$3 1.5937e-17
* device instance cc__22_rst_n r0 *1 0,0
Ccc__22_rst_n \$22 rst_n 1.5937e-17
* device instance cc__22_vss r0 *1 0,0
Ccc__22_vss \$22 vss 3.1875e-17
* device instance cc__24__26 r0 *1 0,0
Ccc__24__26 \$24 \$26 1.0625e-17
* device instance cc__24__48 r0 *1 0,0
Ccc__24__48 \$24 \$48 1.0625e-17
* device instance cc__24_clk r0 *1 0,0
Ccc__24_clk \$24 clk 2.6562e-17
* device instance cc__24_d_vdd r0 *1 0,0
Ccc__24_d_vdd \$24 d|vdd 4.2499e-17
* device instance cc__24_q r0 *1 0,0
Ccc__24_q \$24 q$3 1.0625e-17
* device instance cc__24_rst_n r0 *1 0,0
Ccc__24_rst_n \$24 rst_n 2.125e-17
* device instance cc__24_vss r0 *1 0,0
Ccc__24_vss \$24 vss 2.6562e-17
* device instance cc__25__48 r0 *1 0,0
Ccc__25__48 \$25 \$48 1.0625e-17
* device instance cc__25_clk r0 *1 0,0
Ccc__25_clk \$25 clk 1.0625e-17
* device instance cc__25_d_vdd r0 *1 0,0
Ccc__25_d_vdd \$25 d|vdd 1.0625e-17
* device instance cc__25_q r0 *1 0,0
Ccc__25_q \$25 q$3 1.0625e-17
* device instance cc__25_rst_n r0 *1 0,0
Ccc__25_rst_n \$25 rst_n 5.312e-18
* device instance cc__25_vss r0 *1 0,0
Ccc__25_vss \$25 vss 1.0625e-17
* device instance cc__26__48 r0 *1 0,0
Ccc__26__48 \$26 \$48 1.0625e-17
* device instance cc__26_clk r0 *1 0,0
Ccc__26_clk \$26 clk 1.0625e-17
* device instance cc__26_d_vdd r0 *1 0,0
Ccc__26_d_vdd \$26 d|vdd 1.0625e-17
* device instance cc__26_q r0 *1 0,0
Ccc__26_q \$26 q$3 1.0625e-17
* device instance cc__26_rst_n r0 *1 0,0
Ccc__26_rst_n \$26 rst_n 1.0625e-17
* device instance cc__26_vss r0 *1 0,0
Ccc__26_vss \$26 vss 1.0625e-17
* device instance cc__27__28 r0 *1 0,0
Ccc__27__28 \$27 \$28 3.1875e-17
* device instance cc__27__29 r0 *1 0,0
Ccc__27__29 \$27 \$29 2.125e-17
* device instance cc__27__30 r0 *1 0,0
Ccc__27__30 \$27 \$30 2.125e-17
* device instance cc__27__32 r0 *1 0,0
Ccc__27__32 \$27 \$32 1.0625e-17
* device instance cc__27__33 r0 *1 0,0
Ccc__27__33 \$27 \$33 1.0625e-17
* device instance cc__27__34 r0 *1 0,0
Ccc__27__34 \$27 \$34 1.0625e-17
* device instance cc__27__49 r0 *1 0,0
Ccc__27__49 \$27 \$49 3.1875e-17
* device instance cc__27_a_d_y r0 *1 0,0
Ccc__27_a_d_y \$27 a|d|y 2.125e-17
* device instance cc__27_clk r0 *1 0,0
Ccc__27_clk \$27 clk 3.1875e-17
* device instance cc__27_d_vdd r0 *1 0,0
Ccc__27_d_vdd \$27 d|vdd 1.5937e-17
* device instance cc__27_q r0 *1 0,0
Ccc__27_q \$27 q$3 2.125e-17
* device instance cc__27_rst_n r0 *1 0,0
Ccc__27_rst_n \$27 rst_n 1.5937e-17
* device instance cc__27_vss r0 *1 0,0
Ccc__27_vss \$27 vss 3.1875e-17
* device instance cc__28__29 r0 *1 0,0
Ccc__28__29 \$28 \$29 1.5937e-17
* device instance cc__28__30 r0 *1 0,0
Ccc__28__30 \$28 \$30 1.5937e-17
* device instance cc__28__32 r0 *1 0,0
Ccc__28__32 \$28 \$32 1.0625e-17
* device instance cc__28__33 r0 *1 0,0
Ccc__28__33 \$28 \$33 1.0625e-17
* device instance cc__28__34 r0 *1 0,0
Ccc__28__34 \$28 \$34 1.0625e-17
* device instance cc__28__49 r0 *1 0,0
Ccc__28__49 \$28 \$49 3.1875e-17
* device instance cc__28_a_d_y r0 *1 0,0
Ccc__28_a_d_y \$28 a|d|y 2.6562e-17
* device instance cc__28_clk r0 *1 0,0
Ccc__28_clk \$28 clk 3.1875e-17
* device instance cc__28_d_vdd r0 *1 0,0
Ccc__28_d_vdd \$28 d|vdd 1.5937e-17
* device instance cc__28_q r0 *1 0,0
Ccc__28_q \$28 q$3 2.125e-17
* device instance cc__28_rst_n r0 *1 0,0
Ccc__28_rst_n \$28 rst_n 1.5937e-17
* device instance cc__28_vss r0 *1 0,0
Ccc__28_vss \$28 vss 3.1875e-17
* device instance cc__29__30 r0 *1 0,0
Ccc__29__30 \$29 \$30 1.5937e-17
* device instance cc__29__32 r0 *1 0,0
Ccc__29__32 \$29 \$32 1.0625e-17
* device instance cc__29__33 r0 *1 0,0
Ccc__29__33 \$29 \$33 1.0625e-17
* device instance cc__29__34 r0 *1 0,0
Ccc__29__34 \$29 \$34 1.0625e-17
* device instance cc__29__49 r0 *1 0,0
Ccc__29__49 \$29 \$49 2.125e-17
* device instance cc__29_a_d_y r0 *1 0,0
Ccc__29_a_d_y \$29 a|d|y 2.125e-17
* device instance cc__29_clk r0 *1 0,0
Ccc__29_clk \$29 clk 2.125e-17
* device instance cc__29_d_vdd r0 *1 0,0
Ccc__29_d_vdd \$29 d|vdd 1.0625e-17
* device instance cc__29_q r0 *1 0,0
Ccc__29_q \$29 q$3 1.0625e-17
* device instance cc__29_rst_n r0 *1 0,0
Ccc__29_rst_n \$29 rst_n 1.0625e-17
* device instance cc__29_vss r0 *1 0,0
Ccc__29_vss \$29 vss 2.125e-17
* device instance cc__30__32 r0 *1 0,0
Ccc__30__32 \$30 \$32 1.5937e-17
* device instance cc__30__34 r0 *1 0,0
Ccc__30__34 \$30 \$34 1.0625e-17
* device instance cc__30__49 r0 *1 0,0
Ccc__30__49 \$30 \$49 2.125e-17
* device instance cc__30_a_d_y r0 *1 0,0
Ccc__30_a_d_y \$30 a|d|y 3.1875e-17
* device instance cc__30_clk r0 *1 0,0
Ccc__30_clk \$30 clk 3.1875e-17
* device instance cc__30_d_vdd r0 *1 0,0
Ccc__30_d_vdd \$30 d|vdd 1.5937e-17
* device instance cc__30_q r0 *1 0,0
Ccc__30_q \$30 q$3 1.5937e-17
* device instance cc__30_rst_n r0 *1 0,0
Ccc__30_rst_n \$30 rst_n 1.5937e-17
* device instance cc__30_vss r0 *1 0,0
Ccc__30_vss \$30 vss 3.1875e-17
* device instance cc__32__34 r0 *1 0,0
Ccc__32__34 \$32 \$34 1.0625e-17
* device instance cc__32__49 r0 *1 0,0
Ccc__32__49 \$32 \$49 1.0625e-17
* device instance cc__32_a_d_y r0 *1 0,0
Ccc__32_a_d_y \$32 a|d|y 2.6562e-17
* device instance cc__32_clk r0 *1 0,0
Ccc__32_clk \$32 clk 2.6562e-17
* device instance cc__32_d_vdd r0 *1 0,0
Ccc__32_d_vdd \$32 d|vdd 1.5937e-17
* device instance cc__32_q r0 *1 0,0
Ccc__32_q \$32 q$3 1.0625e-17
* device instance cc__32_rst_n r0 *1 0,0
Ccc__32_rst_n \$32 rst_n 2.125e-17
* device instance cc__32_vss r0 *1 0,0
Ccc__32_vss \$32 vss 2.6562e-17
* device instance cc__33__49 r0 *1 0,0
Ccc__33__49 \$33 \$49 1.0625e-17
* device instance cc__33_a_d_y r0 *1 0,0
Ccc__33_a_d_y \$33 a|d|y 1.0625e-17
* device instance cc__33_clk r0 *1 0,0
Ccc__33_clk \$33 clk 1.0625e-17
* device instance cc__33_q r0 *1 0,0
Ccc__33_q \$33 q$3 1.0625e-17
* device instance cc__33_rst_n r0 *1 0,0
Ccc__33_rst_n \$33 rst_n 5.312e-18
* device instance cc__33_vss r0 *1 0,0
Ccc__33_vss \$33 vss 1.0625e-17
* device instance cc__34__49 r0 *1 0,0
Ccc__34__49 \$34 \$49 1.0625e-17
* device instance cc__34_a_d_y r0 *1 0,0
Ccc__34_a_d_y \$34 a|d|y 1.0625e-17
* device instance cc__34_clk r0 *1 0,0
Ccc__34_clk \$34 clk 1.0625e-17
* device instance cc__34_q r0 *1 0,0
Ccc__34_q \$34 q$3 1.0625e-17
* device instance cc__34_rst_n r0 *1 0,0
Ccc__34_rst_n \$34 rst_n 1.0625e-17
* device instance cc__34_vss r0 *1 0,0
Ccc__34_vss \$34 vss 1.0625e-17
* device instance cc__35__36 r0 *1 0,0
Ccc__35__36 \$35 \$36 3.1875e-17
* device instance cc__35__37 r0 *1 0,0
Ccc__35__37 \$35 \$37 2.125e-17
* device instance cc__35__38 r0 *1 0,0
Ccc__35__38 \$35 \$38 2.125e-17
* device instance cc__35__40 r0 *1 0,0
Ccc__35__40 \$35 \$40 1.0625e-17
* device instance cc__35__41 r0 *1 0,0
Ccc__35__41 \$35 \$41 1.0625e-17
* device instance cc__35__42 r0 *1 0,0
Ccc__35__42 \$35 \$42 1.0625e-17
* device instance cc__35__50 r0 *1 0,0
Ccc__35__50 \$35 \$50 3.1875e-17
* device instance cc__35_b_d_y r0 *1 0,0
Ccc__35_b_d_y \$35 b|d|y 2.125e-17
* device instance cc__35_clk r0 *1 0,0
Ccc__35_clk \$35 clk 3.1875e-17
* device instance cc__35_d_vdd r0 *1 0,0
Ccc__35_d_vdd \$35 d|vdd 1.5937e-17
* device instance cc__35_q r0 *1 0,0
Ccc__35_q \$35 q$3 2.125e-17
* device instance cc__35_rst_n r0 *1 0,0
Ccc__35_rst_n \$35 rst_n 1.5937e-17
* device instance cc__35_vss r0 *1 0,0
Ccc__35_vss \$35 vss 3.1875e-17
* device instance cc__36__37 r0 *1 0,0
Ccc__36__37 \$36 \$37 1.5937e-17
* device instance cc__36__38 r0 *1 0,0
Ccc__36__38 \$36 \$38 1.5937e-17
* device instance cc__36__40 r0 *1 0,0
Ccc__36__40 \$36 \$40 1.0625e-17
* device instance cc__36__41 r0 *1 0,0
Ccc__36__41 \$36 \$41 1.0625e-17
* device instance cc__36__42 r0 *1 0,0
Ccc__36__42 \$36 \$42 1.0625e-17
* device instance cc__36__50 r0 *1 0,0
Ccc__36__50 \$36 \$50 3.1875e-17
* device instance cc__36_b_d_y r0 *1 0,0
Ccc__36_b_d_y \$36 b|d|y 2.6562e-17
* device instance cc__36_clk r0 *1 0,0
Ccc__36_clk \$36 clk 3.1875e-17
* device instance cc__36_d_vdd r0 *1 0,0
Ccc__36_d_vdd \$36 d|vdd 1.5937e-17
* device instance cc__36_q r0 *1 0,0
Ccc__36_q \$36 q$3 2.125e-17
* device instance cc__36_rst_n r0 *1 0,0
Ccc__36_rst_n \$36 rst_n 1.5937e-17
* device instance cc__36_vss r0 *1 0,0
Ccc__36_vss \$36 vss 3.1875e-17
* device instance cc__37__38 r0 *1 0,0
Ccc__37__38 \$37 \$38 1.5937e-17
* device instance cc__37__40 r0 *1 0,0
Ccc__37__40 \$37 \$40 1.0625e-17
* device instance cc__37__41 r0 *1 0,0
Ccc__37__41 \$37 \$41 1.0625e-17
* device instance cc__37__42 r0 *1 0,0
Ccc__37__42 \$37 \$42 1.0625e-17
* device instance cc__37__50 r0 *1 0,0
Ccc__37__50 \$37 \$50 2.125e-17
* device instance cc__37_b_d_y r0 *1 0,0
Ccc__37_b_d_y \$37 b|d|y 2.125e-17
* device instance cc__37_clk r0 *1 0,0
Ccc__37_clk \$37 clk 2.125e-17
* device instance cc__37_d_vdd r0 *1 0,0
Ccc__37_d_vdd \$37 d|vdd 1.0625e-17
* device instance cc__37_q r0 *1 0,0
Ccc__37_q \$37 q$3 1.0625e-17
* device instance cc__37_rst_n r0 *1 0,0
Ccc__37_rst_n \$37 rst_n 1.0625e-17
* device instance cc__37_vss r0 *1 0,0
Ccc__37_vss \$37 vss 2.125e-17
* device instance cc__38__40 r0 *1 0,0
Ccc__38__40 \$38 \$40 1.5937e-17
* device instance cc__38__42 r0 *1 0,0
Ccc__38__42 \$38 \$42 1.0625e-17
* device instance cc__38__50 r0 *1 0,0
Ccc__38__50 \$38 \$50 2.125e-17
* device instance cc__38_b_d_y r0 *1 0,0
Ccc__38_b_d_y \$38 b|d|y 3.1875e-17
* device instance cc__38_clk r0 *1 0,0
Ccc__38_clk \$38 clk 3.1875e-17
* device instance cc__38_d_vdd r0 *1 0,0
Ccc__38_d_vdd \$38 d|vdd 1.5937e-17
* device instance cc__38_q r0 *1 0,0
Ccc__38_q \$38 q$3 1.5937e-17
* device instance cc__38_rst_n r0 *1 0,0
Ccc__38_rst_n \$38 rst_n 1.5937e-17
* device instance cc__38_vss r0 *1 0,0
Ccc__38_vss \$38 vss 3.1875e-17
* device instance cc__40__42 r0 *1 0,0
Ccc__40__42 \$40 \$42 1.0625e-17
* device instance cc__40__50 r0 *1 0,0
Ccc__40__50 \$40 \$50 1.0625e-17
* device instance cc__40_b_d_y r0 *1 0,0
Ccc__40_b_d_y \$40 b|d|y 2.6562e-17
* device instance cc__40_clk r0 *1 0,0
Ccc__40_clk \$40 clk 2.6562e-17
* device instance cc__40_d_vdd r0 *1 0,0
Ccc__40_d_vdd \$40 d|vdd 1.5937e-17
* device instance cc__40_q r0 *1 0,0
Ccc__40_q \$40 q$3 1.0625e-17
* device instance cc__40_rst_n r0 *1 0,0
Ccc__40_rst_n \$40 rst_n 2.125e-17
* device instance cc__40_vss r0 *1 0,0
Ccc__40_vss \$40 vss 2.6562e-17
* device instance cc__41__50 r0 *1 0,0
Ccc__41__50 \$41 \$50 1.0625e-17
* device instance cc__41_b_d_y r0 *1 0,0
Ccc__41_b_d_y \$41 b|d|y 1.0625e-17
* device instance cc__41_clk r0 *1 0,0
Ccc__41_clk \$41 clk 1.0625e-17
* device instance cc__41_q r0 *1 0,0
Ccc__41_q \$41 q$3 1.0625e-17
* device instance cc__41_rst_n r0 *1 0,0
Ccc__41_rst_n \$41 rst_n 5.312e-18
* device instance cc__41_vss r0 *1 0,0
Ccc__41_vss \$41 vss 1.0625e-17
* device instance cc__42__50 r0 *1 0,0
Ccc__42__50 \$42 \$50 1.0625e-17
* device instance cc__42_b_d_y r0 *1 0,0
Ccc__42_b_d_y \$42 b|d|y 1.0625e-17
* device instance cc__42_clk r0 *1 0,0
Ccc__42_clk \$42 clk 1.0625e-17
* device instance cc__42_q r0 *1 0,0
Ccc__42_q \$42 q$3 1.0625e-17
* device instance cc__42_rst_n r0 *1 0,0
Ccc__42_rst_n \$42 rst_n 1.0625e-17
* device instance cc__42_vss r0 *1 0,0
Ccc__42_vss \$42 vss 1.0625e-17
* device instance cc__46_clk r0 *1 0,0
Ccc__46_clk \$46 clk 3.7187e-17
* device instance cc__46_d_vdd r0 *1 0,0
Ccc__46_d_vdd \$46 d|vdd 2.125e-17
* device instance cc__46_d_y r0 *1 0,0
Ccc__46_d_y \$46 d|y 3.7187e-17
* device instance cc__46_q r0 *1 0,0
Ccc__46_q \$46 q$3 2.6562e-17
* device instance cc__46_rst_n r0 *1 0,0
Ccc__46_rst_n \$46 rst_n 2.125e-17
* device instance cc__46_vss r0 *1 0,0
Ccc__46_vss \$46 vss 3.7187e-17
* device instance cc__48_clk r0 *1 0,0
Ccc__48_clk \$48 clk 3.7187e-17
* device instance cc__48_d_vdd r0 *1 0,0
Ccc__48_d_vdd \$48 d|vdd 5.8437e-17
* device instance cc__48_q r0 *1 0,0
Ccc__48_q \$48 q$3 2.6562e-17
* device instance cc__48_rst_n r0 *1 0,0
Ccc__48_rst_n \$48 rst_n 2.125e-17
* device instance cc__48_vss r0 *1 0,0
Ccc__48_vss \$48 vss 3.7187e-17
* device instance cc__49_a_d_y r0 *1 0,0
Ccc__49_a_d_y \$49 a|d|y 3.7187e-17
* device instance cc__49_clk r0 *1 0,0
Ccc__49_clk \$49 clk 3.7187e-17
* device instance cc__49_d_vdd r0 *1 0,0
Ccc__49_d_vdd \$49 d|vdd 2.125e-17
* device instance cc__49_q r0 *1 0,0
Ccc__49_q \$49 q$3 2.6562e-17
* device instance cc__49_rst_n r0 *1 0,0
Ccc__49_rst_n \$49 rst_n 2.125e-17
* device instance cc__49_vss r0 *1 0,0
Ccc__49_vss \$49 vss 3.7187e-17
* device instance cc__5__6 r0 *1 0,0
Ccc__5__6 \$5 \$6 1.5937e-17
* device instance cc__5__7 r0 *1 0,0
Ccc__5__7 \$5 \$7 1.0625e-17
* device instance cc__5__9 r0 *1 0,0
Ccc__5__9 \$5 \$9 1.0625e-17
* device instance cc__5_a_d_y r0 *1 0,0
Ccc__5_a_d_y \$5 a|d|y 2.125e-17
* device instance cc__5_b_d_y r0 *1 0,0
Ccc__5_b_d_y \$5 b|d|y 1.5937e-17
* device instance cc__5_d_vdd r0 *1 0,0
Ccc__5_d_vdd \$5 d|vdd 1.0625e-17
* device instance cc__5_d_y r0 *1 0,0
Ccc__5_d_y \$5 d|y 1.5937e-17
* device instance cc__5_vss r0 *1 0,0
Ccc__5_vss \$5 vss 2.125e-17
* device instance cc__50_b_d_y r0 *1 0,0
Ccc__50_b_d_y \$50 b|d|y 3.7187e-17
* device instance cc__50_clk r0 *1 0,0
Ccc__50_clk \$50 clk 3.7187e-17
* device instance cc__50_d_vdd r0 *1 0,0
Ccc__50_d_vdd \$50 d|vdd 2.125e-17
* device instance cc__50_q r0 *1 0,0
Ccc__50_q \$50 q$3 2.6562e-17
* device instance cc__50_rst_n r0 *1 0,0
Ccc__50_rst_n \$50 rst_n 2.125e-17
* device instance cc__50_vss r0 *1 0,0
Ccc__50_vss \$50 vss 3.7187e-17
* device instance cc__6__7 r0 *1 0,0
Ccc__6__7 \$6 \$7 1.0625e-17
* device instance cc__6__9 r0 *1 0,0
Ccc__6__9 \$6 \$9 1.0625e-17
* device instance cc__6_a_d_y r0 *1 0,0
Ccc__6_a_d_y \$6 a|d|y 2.125e-17
* device instance cc__6_b_d_y r0 *1 0,0
Ccc__6_b_d_y \$6 b|d|y 2.125e-17
* device instance cc__6_d_vdd r0 *1 0,0
Ccc__6_d_vdd \$6 d|vdd 1.0625e-17
* device instance cc__6_d_y r0 *1 0,0
Ccc__6_d_y \$6 d|y 1.5937e-17
* device instance cc__6_vss r0 *1 0,0
Ccc__6_vss \$6 vss 2.125e-17
* device instance cc__7_a_d_y r0 *1 0,0
Ccc__7_a_d_y \$7 a|d|y 1.0625e-17
* device instance cc__7_b_d_y r0 *1 0,0
Ccc__7_b_d_y \$7 b|d|y 1.0625e-17
* device instance cc__7_d_y r0 *1 0,0
Ccc__7_d_y \$7 d|y 5.312e-18
* device instance cc__7_vss r0 *1 0,0
Ccc__7_vss \$7 vss 1.0625e-17
* device instance cc__9_a_d_y r0 *1 0,0
Ccc__9_a_d_y \$9 a|d|y 1.0625e-17
* device instance cc__9_b_d_y r0 *1 0,0
Ccc__9_b_d_y \$9 b|d|y 1.0625e-17
* device instance cc__9_d_y r0 *1 0,0
Ccc__9_d_y \$9 d|y 1.0625e-17
* device instance cc__9_vss r0 *1 0,0
Ccc__9_vss \$9 vss 1.0625e-17
* device instance cc_a_d_y_b_d_y r0 *1 0,0
Ccc_a_d_y_b_d_y a|d|y b|d|y 3.7187e-17
* device instance cc_a_d_y_clk r0 *1 0,0
Ccc_a_d_y_clk a|d|y clk 4.2499e-17
* device instance cc_a_d_y_d_vdd r0 *1 0,0
Ccc_a_d_y_d_vdd a|d|y d|vdd 1.00936e-16
* device instance cc_a_d_y_d_y r0 *1 0,0
Ccc_a_d_y_d_y a|d|y d|y 2.6562e-17
* device instance cc_a_d_y_q r0 *1 0,0
Ccc_a_d_y_q a|d|y q$3 2.125e-17
* device instance cc_a_d_y_rst_n r0 *1 0,0
Ccc_a_d_y_rst_n a|d|y rst_n 3.7187e-17
* device instance cc_a_d_y_vss r0 *1 0,0
Ccc_a_d_y_vss a|d|y vss 7.4374e-17
* device instance cc_b_d_y_clk r0 *1 0,0
Ccc_b_d_y_clk b|d|y clk 4.7812e-17
* device instance cc_b_d_y_d_vdd r0 *1 0,0
Ccc_b_d_y_d_vdd b|d|y d|vdd 1.00936e-16
* device instance cc_b_d_y_d_y r0 *1 0,0
Ccc_b_d_y_d_y b|d|y d|y 2.6562e-17
* device instance cc_b_d_y_q r0 *1 0,0
Ccc_b_d_y_q b|d|y q$3 2.125e-17
* device instance cc_b_d_y_rst_n r0 *1 0,0
Ccc_b_d_y_rst_n b|d|y rst_n 4.2499e-17
* device instance cc_b_d_y_vss r0 *1 0,0
Ccc_b_d_y_vss b|d|y vss 6.9062e-17
* device instance cc_clk_d_vdd r0 *1 0,0
Ccc_clk_d_vdd clk d|vdd 2.12497e-16
* device instance cc_clk_d_y r0 *1 0,0
Ccc_clk_d_y clk d|y 3.1875e-17
* device instance cc_clk_q r0 *1 0,0
Ccc_clk_q clk q$3 8.4999e-17
* device instance cc_clk_rst_n r0 *1 0,0
Ccc_clk_rst_n clk rst_n 1.22186e-16
* device instance cc_clk_vss r0 *1 0,0
Ccc_clk_vss clk vss 1.22186e-16
* device instance cc_d_vdd_d_y r0 *1 0,0
Ccc_d_vdd_d_y d|vdd d|y 7.4374e-17
* device instance cc_d_vdd_q r0 *1 0,0
Ccc_d_vdd_q d|vdd q$3 1.48748e-16
* device instance cc_d_vdd_rst_n r0 *1 0,0
Ccc_d_vdd_rst_n d|vdd rst_n 2.07185e-16
* device instance cc_d_vdd_vss r0 *1 0,0
Ccc_d_vdd_vss d|vdd vss 7.9686e-17
* device instance cc_d_y_q r0 *1 0,0
Ccc_d_y_q d|y q$3 2.125e-17
* device instance cc_d_y_rst_n r0 *1 0,0
Ccc_d_y_rst_n d|y rst_n 2.6562e-17
* device instance cc_d_y_vss r0 *1 0,0
Ccc_d_y_vss d|y vss 4.7812e-17
* device instance cc_q_rst_n r0 *1 0,0
Ccc_q_rst_n q$3 rst_n 6.3749e-17
* device instance cc_q_vss r0 *1 0,0
Ccc_q_vss q$3 vss 4.2499e-17
* device instance cc_rst_n_vss r0 *1 0,0
Ccc_rst_n_vss rst_n vss 5.8437e-17
* device instance vsubs_dctie r0 *1 0,0
Rvsubs_dctie vsubs 0 1e+12
.ENDS combiner_sampler
