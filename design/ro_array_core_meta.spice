* ro_array_core_meta -- GENERATED by design/netlist.py from design/xschem/ro_array_core_meta.sch
* Do not edit by hand: `python3 design/netlist.py --check` fails if this
* file and the schematic disagree. Regenerate with `python3 design/netlist.py`.
** sch_path: ro_array_core_meta.sch
.subckt ro_array_core_meta en1 en2 vddr1 vddr2 vdd vddm vss xo mo cta=2f ctb=2f cld=0.5f
*.ipin en1
*.ipin en2
*.iopin vddr1
*.iopin vddr2
*.iopin vdd
*.iopin vddm
*.iopin vss
*.opin xo
*.opin mo
xcore en1 en2 vddr1 vddr2 vdd vss xo ro_array_core
xtap xo mo vddm vss ro_meta_tap cta=cta ctb=ctb cld=cld
.ends

* expanding   symbol:  ro_array_core.sym # of pins=7
** sym_path: ro_array_core.sym
** sch_path: ro_array_core.sch
.subckt ro_array_core en1 en2 vddr1 vddr2 vdd vss xo
*.ipin en1
*.ipin en2
*.iopin vddr1
*.iopin vddr2
*.iopin vdd
*.iopin vss
*.opin xo
xr1 en1 ro1 vddr1 vss ro_ring11 wstv=0.220u lstv=2u cld=0.5f
xr2 en2 ro2 vddr2 vss ro_ring11 wstv=0.240u lstv=2u cld=0.5f
xa1 ro1 ro2 xo vdd vss xor2
.ends

* expanding   symbol:  ro_meta_tap.sym # of pins=4
** sym_path: ro_meta_tap.sym
** sch_path: ro_meta_tap.sch
.subckt ro_meta_tap xin mo vddm vss cta=2f ctb=2f cld=0.5f
*.ipin xin
*.opin mo
*.iopin vddm
*.iopin vss
xbi xin s0 vddm vss meta_inv cld=cld
xa1 s0 a1 vddm vss meta_inv cld=cta
xa2 a1 pa vddm vss meta_inv cld=cld
xb1 s0 b1 vddm vss meta_inv cld=ctb
xb2 b1 pb vddm vss meta_inv cld=cld
xarb pa pb mq mqn vddm vss meta_arb cld=cld
xbo mq mo vddm vss meta_inv cld=cld
.ends

* expanding   symbol:  ro_ring11.sym # of pins=4
** sym_path: ro_ring11.sym
** sch_path: ro_ring11.sch
.subckt ro_ring11 en ro vddr vss wstv=0.22u lstv=2u cld=0.5f
*.ipin en
*.opin ro
*.iopin vddr
*.iopin vss
xg ro en n1 vddr vss ro_nand2 wstv=wstv lstv=lstv cld=cld
x1 n1 n2 vddr vss ro_stage wstv=wstv lstv=lstv cld=cld
x2 n2 n3 vddr vss ro_stage wstv=wstv lstv=lstv cld=cld
x3 n3 n4 vddr vss ro_stage wstv=wstv lstv=lstv cld=cld
x4 n4 n5 vddr vss ro_stage wstv=wstv lstv=lstv cld=cld
x5 n5 n6 vddr vss ro_stage wstv=wstv lstv=lstv cld=cld
x6 n6 n7 vddr vss ro_stage wstv=wstv lstv=lstv cld=cld
x7 n7 n8 vddr vss ro_stage wstv=wstv lstv=lstv cld=cld
x8 n8 n9 vddr vss ro_stage wstv=wstv lstv=lstv cld=cld
x9 n9 n10 vddr vss ro_stage wstv=wstv lstv=lstv cld=cld
x10 n10 ro vddr vss ro_stage wstv=wstv lstv=lstv cld=cld
.ends

* expanding   symbol:  xor2.sym # of pins=5
** sym_path: xor2.sym
** sch_path: xor2.sch
.subckt xor2 a b y vdd vss
*.ipin a
*.ipin b
*.opin y
*.iopin vdd
*.iopin vss
XMpiA an a vdd vdd pfet_03v3 L=0.28u W=0.44u nf=1 ad='int((nf+1)/2) * W/nf * 0.18u' as='int((nf+2)/2) * W/nf * 0.18u'
+ pd='2*int((nf+1)/2) * (W/nf + 0.18u)' ps='2*int((nf+2)/2) * (W/nf + 0.18u)' nrd='0.18u / W' nrs='0.18u / W' sa=0 sb=0
+ sd=0 m=1
XMniA an a vss vss nfet_03v3 L=0.28u W=0.22u nf=1 ad='int((nf+1)/2) * W/nf * 0.18u' as='int((nf+2)/2) * W/nf * 0.18u'
+ pd='2*int((nf+1)/2) * (W/nf + 0.18u)' ps='2*int((nf+2)/2) * (W/nf + 0.18u)' nrd='0.18u / W' nrs='0.18u / W' sa=0 sb=0
+ sd=0 m=1
XMpiB bn b vdd vdd pfet_03v3 L=0.28u W=0.44u nf=1 ad='int((nf+1)/2) * W/nf * 0.18u' as='int((nf+2)/2) * W/nf * 0.18u'
+ pd='2*int((nf+1)/2) * (W/nf + 0.18u)' ps='2*int((nf+2)/2) * (W/nf + 0.18u)' nrd='0.18u / W' nrs='0.18u / W' sa=0 sb=0
+ sd=0 m=1
XMniB bn b vss vss nfet_03v3 L=0.28u W=0.22u nf=1 ad='int((nf+1)/2) * W/nf * 0.18u' as='int((nf+2)/2) * W/nf * 0.18u'
+ pd='2*int((nf+1)/2) * (W/nf + 0.18u)' ps='2*int((nf+2)/2) * (W/nf + 0.18u)' nrd='0.18u / W' nrs='0.18u / W' sa=0 sb=0
+ sd=0 m=1
XMp1 mid a vdd vdd pfet_03v3 L=0.28u W=0.88u nf=1 ad='int((nf+1)/2) * W/nf * 0.18u' as='int((nf+2)/2) * W/nf * 0.18u'
+ pd='2*int((nf+1)/2) * (W/nf + 0.18u)' ps='2*int((nf+2)/2) * (W/nf + 0.18u)' nrd='0.18u / W' nrs='0.18u / W' sa=0 sb=0
+ sd=0 m=1
XMp2 mid b vdd vdd pfet_03v3 L=0.28u W=0.88u nf=1 ad='int((nf+1)/2) * W/nf * 0.18u' as='int((nf+2)/2) * W/nf * 0.18u'
+ pd='2*int((nf+1)/2) * (W/nf + 0.18u)' ps='2*int((nf+2)/2) * (W/nf + 0.18u)' nrd='0.18u / W' nrs='0.18u / W' sa=0 sb=0
+ sd=0 m=1
XMp3 y an mid vdd pfet_03v3 L=0.28u W=0.88u nf=1 ad='int((nf+1)/2) * W/nf * 0.18u' as='int((nf+2)/2) * W/nf * 0.18u'
+ pd='2*int((nf+1)/2) * (W/nf + 0.18u)' ps='2*int((nf+2)/2) * (W/nf + 0.18u)' nrd='0.18u / W' nrs='0.18u / W' sa=0 sb=0
+ sd=0 m=1
XMp4 y bn mid vdd pfet_03v3 L=0.28u W=0.88u nf=1 ad='int((nf+1)/2) * W/nf * 0.18u' as='int((nf+2)/2) * W/nf * 0.18u'
+ pd='2*int((nf+1)/2) * (W/nf + 0.18u)' ps='2*int((nf+2)/2) * (W/nf + 0.18u)' nrd='0.18u / W' nrs='0.18u / W' sa=0 sb=0
+ sd=0 m=1
XMn1 y a s1 vss nfet_03v3 L=0.28u W=0.44u nf=1 ad='int((nf+1)/2) * W/nf * 0.18u' as='int((nf+2)/2) * W/nf * 0.18u'
+ pd='2*int((nf+1)/2) * (W/nf + 0.18u)' ps='2*int((nf+2)/2) * (W/nf + 0.18u)' nrd='0.18u / W' nrs='0.18u / W' sa=0 sb=0
+ sd=0 m=1
XMn2 s1 b vss vss nfet_03v3 L=0.28u W=0.44u nf=1 ad='int((nf+1)/2) * W/nf * 0.18u' as='int((nf+2)/2) * W/nf * 0.18u'
+ pd='2*int((nf+1)/2) * (W/nf + 0.18u)' ps='2*int((nf+2)/2) * (W/nf + 0.18u)' nrd='0.18u / W' nrs='0.18u / W' sa=0 sb=0
+ sd=0 m=1
XMn3 y an s2 vss nfet_03v3 L=0.28u W=0.44u nf=1 ad='int((nf+1)/2) * W/nf * 0.18u' as='int((nf+2)/2) * W/nf * 0.18u'
+ pd='2*int((nf+1)/2) * (W/nf + 0.18u)' ps='2*int((nf+2)/2) * (W/nf + 0.18u)' nrd='0.18u / W' nrs='0.18u / W' sa=0 sb=0
+ sd=0 m=1
XMn4 s2 bn vss vss nfet_03v3 L=0.28u W=0.44u nf=1 ad='int((nf+1)/2) * W/nf * 0.18u' as='int((nf+2)/2) * W/nf * 0.18u'
+ pd='2*int((nf+1)/2) * (W/nf + 0.18u)' ps='2*int((nf+2)/2) * (W/nf + 0.18u)' nrd='0.18u / W' nrs='0.18u / W' sa=0 sb=0
+ sd=0 m=1
.ends

* expanding   symbol:  meta_inv.sym # of pins=4
** sym_path: meta_inv.sym
** sch_path: meta_inv.sch
.subckt meta_inv a y vdd vss cld=0.5f
*.ipin a
*.opin y
*.iopin vdd
*.iopin vss
XMp y a vdd vdd pfet_03v3 L=0.28u W=0.44u nf=1 ad='int((nf+1)/2) * W/nf * 0.18u' as='int((nf+2)/2) * W/nf * 0.18u'
+ pd='2*int((nf+1)/2) * (W/nf + 0.18u)' ps='2*int((nf+2)/2) * (W/nf + 0.18u)' nrd='0.18u / W' nrs='0.18u / W' sa=0 sb=0
+ sd=0 m=1
XMn y a vss vss nfet_03v3 L=0.28u W=0.22u nf=1 ad='int((nf+1)/2) * W/nf * 0.18u' as='int((nf+2)/2) * W/nf * 0.18u'
+ pd='2*int((nf+1)/2) * (W/nf + 0.18u)' ps='2*int((nf+2)/2) * (W/nf + 0.18u)' nrd='0.18u / W' nrs='0.18u / W' sa=0 sb=0
+ sd=0 m=1
Cld y vss 'cld' m=1
.ends

* expanding   symbol:  meta_arb.sym # of pins=6
** sym_path: meta_arb.sym
** sch_path: meta_arb.sch
.subckt meta_arb sn rn q qn vdd vss cld=0.5f
*.ipin sn
*.ipin rn
*.opin q
*.opin qn
*.iopin vdd
*.iopin vss
xna sn qn q vdd vss meta_nand2 cld=cld
xnb rn q qn vdd vss meta_nand2 cld=cld
.ends

* expanding   symbol:  ro_nand2.sym # of pins=5
** sym_path: ro_nand2.sym
** sch_path: ro_nand2.sch
.subckt ro_nand2 a en y vddr vss wstv=0.22u lstv=2u cld=0.5f
*.ipin a
*.ipin en
*.opin y
*.iopin vddr
*.iopin vss
XMph py vss vddr vddr pfet_03v3 L=lstv W=wstv nf=1 ad='int((nf+1)/2) * W/nf * 0.18u' as='int((nf+2)/2) * W/nf * 0.18u'
+ pd='2*int((nf+1)/2) * (W/nf + 0.18u)' ps='2*int((nf+2)/2) * (W/nf + 0.18u)' nrd='0.18u / W' nrs='0.18u / W' sa=0 sb=0
+ sd=0 m=1
XMpa y a py vddr pfet_03v3 L=0.28u W=0.44u nf=1 ad='int((nf+1)/2) * W/nf * 0.18u' as='int((nf+2)/2) * W/nf * 0.18u'
+ pd='2*int((nf+1)/2) * (W/nf + 0.18u)' ps='2*int((nf+2)/2) * (W/nf + 0.18u)' nrd='0.18u / W' nrs='0.18u / W' sa=0 sb=0
+ sd=0 m=1
XMpb y en py vddr pfet_03v3 L=0.28u W=0.44u nf=1 ad='int((nf+1)/2) * W/nf * 0.18u' as='int((nf+2)/2) * W/nf * 0.18u'
+ pd='2*int((nf+1)/2) * (W/nf + 0.18u)' ps='2*int((nf+2)/2) * (W/nf + 0.18u)' nrd='0.18u / W' nrs='0.18u / W' sa=0 sb=0
+ sd=0 m=1
XMna y a nm vss nfet_03v3 L=0.28u W=0.44u nf=1 ad='int((nf+1)/2) * W/nf * 0.18u' as='int((nf+2)/2) * W/nf * 0.18u'
+ pd='2*int((nf+1)/2) * (W/nf + 0.18u)' ps='2*int((nf+2)/2) * (W/nf + 0.18u)' nrd='0.18u / W' nrs='0.18u / W' sa=0 sb=0
+ sd=0 m=1
XMnb nm en ny vss nfet_03v3 L=0.28u W=0.44u nf=1 ad='int((nf+1)/2) * W/nf * 0.18u' as='int((nf+2)/2) * W/nf * 0.18u'
+ pd='2*int((nf+1)/2) * (W/nf + 0.18u)' ps='2*int((nf+2)/2) * (W/nf + 0.18u)' nrd='0.18u / W' nrs='0.18u / W' sa=0 sb=0
+ sd=0 m=1
XMnt ny vddr vss vss nfet_03v3 L=lstv W=wstv nf=1 ad='int((nf+1)/2) * W/nf * 0.18u' as='int((nf+2)/2) * W/nf * 0.18u'
+ pd='2*int((nf+1)/2) * (W/nf + 0.18u)' ps='2*int((nf+2)/2) * (W/nf + 0.18u)' nrd='0.18u / W' nrs='0.18u / W' sa=0 sb=0
+ sd=0 m=1
Cld y vss 'cld' m=1
.ends

* expanding   symbol:  ro_stage.sym # of pins=4
** sym_path: ro_stage.sym
** sch_path: ro_stage.sch
.subckt ro_stage a y vddr vss wstv=0.22u lstv=2u cld=0.5f
*.ipin a
*.opin y
*.iopin vddr
*.iopin vss
XMph py vss vddr vddr pfet_03v3 L=lstv W=wstv nf=1 ad='int((nf+1)/2) * W/nf * 0.18u' as='int((nf+2)/2) * W/nf * 0.18u'
+ pd='2*int((nf+1)/2) * (W/nf + 0.18u)' ps='2*int((nf+2)/2) * (W/nf + 0.18u)' nrd='0.18u / W' nrs='0.18u / W' sa=0 sb=0
+ sd=0 m=1
XMp y a py vddr pfet_03v3 L=0.28u W=0.44u nf=1 ad='int((nf+1)/2) * W/nf * 0.18u' as='int((nf+2)/2) * W/nf * 0.18u'
+ pd='2*int((nf+1)/2) * (W/nf + 0.18u)' ps='2*int((nf+2)/2) * (W/nf + 0.18u)' nrd='0.18u / W' nrs='0.18u / W' sa=0 sb=0
+ sd=0 m=1
XMn y a ny vss nfet_03v3 L=0.28u W=0.22u nf=1 ad='int((nf+1)/2) * W/nf * 0.18u' as='int((nf+2)/2) * W/nf * 0.18u'
+ pd='2*int((nf+1)/2) * (W/nf + 0.18u)' ps='2*int((nf+2)/2) * (W/nf + 0.18u)' nrd='0.18u / W' nrs='0.18u / W' sa=0 sb=0
+ sd=0 m=1
XMnt ny vddr vss vss nfet_03v3 L=lstv W=wstv nf=1 ad='int((nf+1)/2) * W/nf * 0.18u' as='int((nf+2)/2) * W/nf * 0.18u'
+ pd='2*int((nf+1)/2) * (W/nf + 0.18u)' ps='2*int((nf+2)/2) * (W/nf + 0.18u)' nrd='0.18u / W' nrs='0.18u / W' sa=0 sb=0
+ sd=0 m=1
Cld y vss 'cld' m=1
.ends

* expanding   symbol:  meta_nand2.sym # of pins=5
** sym_path: meta_nand2.sym
** sch_path: meta_nand2.sch
.subckt meta_nand2 a b y vdd vss cld=0.5f
*.ipin a
*.ipin b
*.opin y
*.iopin vdd
*.iopin vss
XMpa y a vdd vdd pfet_03v3 L=0.28u W=0.44u nf=1 ad='int((nf+1)/2) * W/nf * 0.18u' as='int((nf+2)/2) * W/nf * 0.18u'
+ pd='2*int((nf+1)/2) * (W/nf + 0.18u)' ps='2*int((nf+2)/2) * (W/nf + 0.18u)' nrd='0.18u / W' nrs='0.18u / W' sa=0 sb=0
+ sd=0 m=1
XMpb y b vdd vdd pfet_03v3 L=0.28u W=0.44u nf=1 ad='int((nf+1)/2) * W/nf * 0.18u' as='int((nf+2)/2) * W/nf * 0.18u'
+ pd='2*int((nf+1)/2) * (W/nf + 0.18u)' ps='2*int((nf+2)/2) * (W/nf + 0.18u)' nrd='0.18u / W' nrs='0.18u / W' sa=0 sb=0
+ sd=0 m=1
XMna y a nm vss nfet_03v3 L=0.28u W=0.44u nf=1 ad='int((nf+1)/2) * W/nf * 0.18u' as='int((nf+2)/2) * W/nf * 0.18u'
+ pd='2*int((nf+1)/2) * (W/nf + 0.18u)' ps='2*int((nf+2)/2) * (W/nf + 0.18u)' nrd='0.18u / W' nrs='0.18u / W' sa=0 sb=0
+ sd=0 m=1
XMnb nm b vss vss nfet_03v3 L=0.28u W=0.44u nf=1 ad='int((nf+1)/2) * W/nf * 0.18u' as='int((nf+2)/2) * W/nf * 0.18u'
+ pd='2*int((nf+1)/2) * (W/nf + 0.18u)' ps='2*int((nf+2)/2) * (W/nf + 0.18u)' nrd='0.18u / W' nrs='0.18u / W' sa=0 sb=0
+ sd=0 m=1
Cld y vss 'cld' m=1
.ends
