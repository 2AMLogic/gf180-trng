* power_switch -- GENERATED by design/netlist.py from design/xschem/power_switch.sch
* Do not edit by hand: `python3 design/netlist.py --check` fails if this
* file and the schematic disagree. Regenerate with `python3 design/netlist.py`.
** sch_path: power_switch.sch
.subckt power_switch sleep vdd vvdd wf=10u nfing=40 lsw=0.28u
*.ipin sleep
*.iopin vdd
*.iopin vvdd
XMp vvdd sleep vdd vdd pfet_03v3 L=lsw W=wf nf=1 ad='int((nf+1)/2) * W/nf * 0.18u' as='int((nf+2)/2) * W/nf * 0.18u'
+ pd='2*int((nf+1)/2) * (W/nf + 0.18u)' ps='2*int((nf+2)/2) * (W/nf + 0.18u)' nrd='0.18u / W' nrs='0.18u / W' sa=0 sb=0
+ sd=0 m=nfing
.ends
