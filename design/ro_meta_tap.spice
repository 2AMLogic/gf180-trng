* ro_meta_tap -- GENERATED by design/netlist.py from design/xschem/ro_meta_tap.sch
* Do not edit by hand: `python3 design/netlist.py --check` fails if this
* file and the schematic disagree. Regenerate with `python3 design/netlist.py`.
** sch_path: ro_meta_tap.sch
.subckt ro_meta_tap xin mo vddm vss cta=2f ctb=2f cld=0.5f
*.ipin xin
*.opin mo
*.iopin vddm
*.iopin vss
xbi xin s0 vddm vss meta_inv cld=cld
xa1 s0 a1 vddm vss meta_inv cld=cta
xa2 a1 pa vddm vss meta_inv cld=cld
xb1 s0 b1 vddm vss meta_inv cld=ctb
xb2 b1 pb vddm vss meta_inv cld=cld
xarb pa pb mq mqn vddm vss meta_arb cld=cld
xbo mq mo vddm vss meta_inv cld=cld
.ends

* expanding   symbol:  meta_inv.sym # of pins=4
** sym_path: meta_inv.sym
** sch_path: meta_inv.sch
.subckt meta_inv a y vdd vss cld=0.5f
*.ipin a
*.opin y
*.iopin vdd
*.iopin vss
XMp y a vdd vdd pfet_03v3 L=0.28u W=0.44u nf=1 ad='int((nf+1)/2) * W/nf * 0.18u' as='int((nf+2)/2) * W/nf * 0.18u'
+ pd='2*int((nf+1)/2) * (W/nf + 0.18u)' ps='2*int((nf+2)/2) * (W/nf + 0.18u)' nrd='0.18u / W' nrs='0.18u / W' sa=0 sb=0
+ sd=0 m=1
XMn y a vss vss nfet_03v3 L=0.28u W=0.22u nf=1 ad='int((nf+1)/2) * W/nf * 0.18u' as='int((nf+2)/2) * W/nf * 0.18u'
+ pd='2*int((nf+1)/2) * (W/nf + 0.18u)' ps='2*int((nf+2)/2) * (W/nf + 0.18u)' nrd='0.18u / W' nrs='0.18u / W' sa=0 sb=0
+ sd=0 m=1
Cld y vss 'cld' m=1
.ends

* expanding   symbol:  meta_arb.sym # of pins=6
** sym_path: meta_arb.sym
** sch_path: meta_arb.sch
.subckt meta_arb sn rn q qn vdd vss cld=0.5f
*.ipin sn
*.ipin rn
*.opin q
*.opin qn
*.iopin vdd
*.iopin vss
xna sn qn q vdd vss meta_nand2 cld=cld
xnb rn q qn vdd vss meta_nand2 cld=cld
.ends

* expanding   symbol:  meta_nand2.sym # of pins=5
** sym_path: meta_nand2.sym
** sch_path: meta_nand2.sch
.subckt meta_nand2 a b y vdd vss cld=0.5f
*.ipin a
*.ipin b
*.opin y
*.iopin vdd
*.iopin vss
XMpa y a vdd vdd pfet_03v3 L=0.28u W=0.44u nf=1 ad='int((nf+1)/2) * W/nf * 0.18u' as='int((nf+2)/2) * W/nf * 0.18u'
+ pd='2*int((nf+1)/2) * (W/nf + 0.18u)' ps='2*int((nf+2)/2) * (W/nf + 0.18u)' nrd='0.18u / W' nrs='0.18u / W' sa=0 sb=0
+ sd=0 m=1
XMpb y b vdd vdd pfet_03v3 L=0.28u W=0.44u nf=1 ad='int((nf+1)/2) * W/nf * 0.18u' as='int((nf+2)/2) * W/nf * 0.18u'
+ pd='2*int((nf+1)/2) * (W/nf + 0.18u)' ps='2*int((nf+2)/2) * (W/nf + 0.18u)' nrd='0.18u / W' nrs='0.18u / W' sa=0 sb=0
+ sd=0 m=1
XMna y a nm vss nfet_03v3 L=0.28u W=0.44u nf=1 ad='int((nf+1)/2) * W/nf * 0.18u' as='int((nf+2)/2) * W/nf * 0.18u'
+ pd='2*int((nf+1)/2) * (W/nf + 0.18u)' ps='2*int((nf+2)/2) * (W/nf + 0.18u)' nrd='0.18u / W' nrs='0.18u / W' sa=0 sb=0
+ sd=0 m=1
XMnb nm b vss vss nfet_03v3 L=0.28u W=0.44u nf=1 ad='int((nf+1)/2) * W/nf * 0.18u' as='int((nf+2)/2) * W/nf * 0.18u'
+ pd='2*int((nf+1)/2) * (W/nf + 0.18u)' ps='2*int((nf+2)/2) * (W/nf + 0.18u)' nrd='0.18u / W' nrs='0.18u / W' sa=0 sb=0
+ sd=0 m=1
Cld y vss 'cld' m=1
.ends
